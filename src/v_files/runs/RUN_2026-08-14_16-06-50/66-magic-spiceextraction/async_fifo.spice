* NGSPICE file created from async_fifo.ext - technology: sky130A

* Black-box entry subcircuit for sky130_fd_sc_hd__mux2_1 abstract view
.subckt sky130_fd_sc_hd__mux2_1 A0 A1 S VGND VNB VPB VPWR X
.ends

* Black-box entry subcircuit for sky130_fd_sc_hd__decap_6 abstract view
.subckt sky130_fd_sc_hd__decap_6 VGND VNB VPB VPWR
.ends

* Black-box entry subcircuit for sky130_fd_sc_hd__xor2_1 abstract view
.subckt sky130_fd_sc_hd__xor2_1 A B VGND VNB VPB VPWR X
.ends

* Black-box entry subcircuit for sky130_fd_sc_hd__or2_1 abstract view
.subckt sky130_fd_sc_hd__or2_1 A B VGND VNB VPB VPWR X
.ends

* Black-box entry subcircuit for sky130_fd_sc_hd__decap_4 abstract view
.subckt sky130_fd_sc_hd__decap_4 VGND VNB VPB VPWR
.ends

* Black-box entry subcircuit for sky130_fd_sc_hd__decap_3 abstract view
.subckt sky130_fd_sc_hd__decap_3 VGND VNB VPB VPWR
.ends

* Black-box entry subcircuit for sky130_fd_sc_hd__tapvpwrvgnd_1 abstract view
.subckt sky130_fd_sc_hd__tapvpwrvgnd_1 VGND VPWR
.ends

* Black-box entry subcircuit for sky130_fd_sc_hd__nand4_4 abstract view
.subckt sky130_fd_sc_hd__nand4_4 A B C D VGND VNB VPB VPWR Y
.ends

* Black-box entry subcircuit for sky130_fd_sc_hd__mux4_1 abstract view
.subckt sky130_fd_sc_hd__mux4_1 A0 A1 A2 A3 S0 S1 VGND VNB VPB VPWR X
.ends

* Black-box entry subcircuit for sky130_fd_sc_hd__a21boi_2 abstract view
.subckt sky130_fd_sc_hd__a21boi_2 A1 A2 B1_N VGND VNB VPB VPWR Y
.ends

* Black-box entry subcircuit for sky130_ef_sc_hd__decap_12 abstract view
.subckt sky130_ef_sc_hd__decap_12 VPWR VGND VPB VNB
.ends

* Black-box entry subcircuit for sky130_fd_sc_hd__dfxtp_1 abstract view
.subckt sky130_fd_sc_hd__dfxtp_1 CLK D VGND VNB VPB VPWR Q
.ends

* Black-box entry subcircuit for sky130_fd_sc_hd__fill_1 abstract view
.subckt sky130_fd_sc_hd__fill_1 VGND VNB VPB VPWR
.ends

* Black-box entry subcircuit for sky130_fd_sc_hd__fill_2 abstract view
.subckt sky130_fd_sc_hd__fill_2 VGND VNB VPB VPWR
.ends

* Black-box entry subcircuit for sky130_fd_sc_hd__dfrtp_1 abstract view
.subckt sky130_fd_sc_hd__dfrtp_1 CLK D RESET_B VGND VNB VPB VPWR Q
.ends

* Black-box entry subcircuit for sky130_fd_sc_hd__decap_8 abstract view
.subckt sky130_fd_sc_hd__decap_8 VGND VNB VPB VPWR
.ends

* Black-box entry subcircuit for sky130_fd_sc_hd__buf_1 abstract view
.subckt sky130_fd_sc_hd__buf_1 A VGND VNB VPB VPWR X
.ends

* Black-box entry subcircuit for sky130_fd_sc_hd__xnor2_1 abstract view
.subckt sky130_fd_sc_hd__xnor2_1 A B VGND VNB VPB VPWR Y
.ends

* Black-box entry subcircuit for sky130_fd_sc_hd__a22o_1 abstract view
.subckt sky130_fd_sc_hd__a22o_1 A1 A2 B1 B2 VGND VNB VPB VPWR X
.ends

* Black-box entry subcircuit for sky130_fd_sc_hd__dfrtp_2 abstract view
.subckt sky130_fd_sc_hd__dfrtp_2 CLK D RESET_B VGND VNB VPB VPWR Q
.ends

* Black-box entry subcircuit for sky130_fd_sc_hd__clkbuf_16 abstract view
.subckt sky130_fd_sc_hd__clkbuf_16 A VGND VNB VPB VPWR X
.ends

* Black-box entry subcircuit for sky130_fd_sc_hd__clkbuf_8 abstract view
.subckt sky130_fd_sc_hd__clkbuf_8 A VGND VNB VPB VPWR X
.ends

* Black-box entry subcircuit for sky130_fd_sc_hd__inv_2 abstract view
.subckt sky130_fd_sc_hd__inv_2 A VGND VNB VPB VPWR Y
.ends

* Black-box entry subcircuit for sky130_fd_sc_hd__dfrtp_4 abstract view
.subckt sky130_fd_sc_hd__dfrtp_4 CLK D RESET_B VGND VNB VPB VPWR Q
.ends

* Black-box entry subcircuit for sky130_fd_sc_hd__and4bb_4 abstract view
.subckt sky130_fd_sc_hd__and4bb_4 A_N B_N C D VGND VNB VPB VPWR X
.ends

* Black-box entry subcircuit for sky130_fd_sc_hd__a221o_1 abstract view
.subckt sky130_fd_sc_hd__a221o_1 A1 A2 B1 B2 C1 VGND VNB VPB VPWR X
.ends

* Black-box entry subcircuit for sky130_fd_sc_hd__and2_1 abstract view
.subckt sky130_fd_sc_hd__and2_1 A B VGND VNB VPB VPWR X
.ends

* Black-box entry subcircuit for sky130_fd_sc_hd__and2b_1 abstract view
.subckt sky130_fd_sc_hd__and2b_1 A_N B VGND VNB VPB VPWR X
.ends

* Black-box entry subcircuit for sky130_fd_sc_hd__o221ai_2 abstract view
.subckt sky130_fd_sc_hd__o221ai_2 A1 A2 B1 B2 C1 VGND VNB VPB VPWR Y
.ends

* Black-box entry subcircuit for sky130_fd_sc_hd__a41o_1 abstract view
.subckt sky130_fd_sc_hd__a41o_1 A1 A2 A3 A4 B1 VGND VNB VPB VPWR X
.ends

* Black-box entry subcircuit for sky130_fd_sc_hd__nand2_1 abstract view
.subckt sky130_fd_sc_hd__nand2_1 A B VGND VNB VPB VPWR Y
.ends

* Black-box entry subcircuit for sky130_fd_sc_hd__clkinv_2 abstract view
.subckt sky130_fd_sc_hd__clkinv_2 A VGND VNB VPB VPWR Y
.ends

* Black-box entry subcircuit for sky130_fd_sc_hd__nor2_1 abstract view
.subckt sky130_fd_sc_hd__nor2_1 A B VGND VNB VPB VPWR Y
.ends

* Black-box entry subcircuit for sky130_fd_sc_hd__o21a_1 abstract view
.subckt sky130_fd_sc_hd__o21a_1 A1 A2 B1 VGND VNB VPB VPWR X
.ends

* Black-box entry subcircuit for sky130_fd_sc_hd__bufinv_16 abstract view
.subckt sky130_fd_sc_hd__bufinv_16 A VGND VNB VPB VPWR Y
.ends

* Black-box entry subcircuit for sky130_fd_sc_hd__nand2b_1 abstract view
.subckt sky130_fd_sc_hd__nand2b_1 A_N B VGND VNB VPB VPWR Y
.ends

* Black-box entry subcircuit for sky130_fd_sc_hd__nand4b_4 abstract view
.subckt sky130_fd_sc_hd__nand4b_4 A_N B C D VGND VNB VPB VPWR Y
.ends

* Black-box entry subcircuit for sky130_fd_sc_hd__clkinv_4 abstract view
.subckt sky130_fd_sc_hd__clkinv_4 A VGND VNB VPB VPWR Y
.ends

* Black-box entry subcircuit for sky130_fd_sc_hd__o2111a_1 abstract view
.subckt sky130_fd_sc_hd__o2111a_1 A1 A2 B1 C1 D1 VGND VNB VPB VPWR X
.ends

* Black-box entry subcircuit for sky130_fd_sc_hd__nor2_2 abstract view
.subckt sky130_fd_sc_hd__nor2_2 A B VGND VNB VPB VPWR Y
.ends

* Black-box entry subcircuit for sky130_fd_sc_hd__clkinvlp_4 abstract view
.subckt sky130_fd_sc_hd__clkinvlp_4 A VGND VNB VPB VPWR Y
.ends

* Black-box entry subcircuit for sky130_fd_sc_hd__and4b_4 abstract view
.subckt sky130_fd_sc_hd__and4b_4 A_N B C D VGND VNB VPB VPWR X
.ends

* Black-box entry subcircuit for sky130_fd_sc_hd__a21oi_1 abstract view
.subckt sky130_fd_sc_hd__a21oi_1 A1 A2 B1 VGND VNB VPB VPWR Y
.ends

* Black-box entry subcircuit for sky130_fd_sc_hd__clkbuf_1 abstract view
.subckt sky130_fd_sc_hd__clkbuf_1 A VGND VNB VPB VPWR X
.ends

* Black-box entry subcircuit for sky130_fd_sc_hd__inv_4 abstract view
.subckt sky130_fd_sc_hd__inv_4 A VGND VNB VPB VPWR Y
.ends

* Black-box entry subcircuit for sky130_fd_sc_hd__clkbuf_4 abstract view
.subckt sky130_fd_sc_hd__clkbuf_4 A VGND VNB VPB VPWR X
.ends

* Black-box entry subcircuit for sky130_fd_sc_hd__and2_2 abstract view
.subckt sky130_fd_sc_hd__and2_2 A B VGND VNB VPB VPWR X
.ends

* Black-box entry subcircuit for sky130_fd_sc_hd__buf_8 abstract view
.subckt sky130_fd_sc_hd__buf_8 A VGND VNB VPB VPWR X
.ends

* Black-box entry subcircuit for sky130_fd_sc_hd__a31o_1 abstract view
.subckt sky130_fd_sc_hd__a31o_1 A1 A2 A3 B1 VGND VNB VPB VPWR X
.ends

* Black-box entry subcircuit for sky130_fd_sc_hd__and3_1 abstract view
.subckt sky130_fd_sc_hd__and3_1 A B C VGND VNB VPB VPWR X
.ends

* Black-box entry subcircuit for sky130_fd_sc_hd__o31a_1 abstract view
.subckt sky130_fd_sc_hd__o31a_1 A1 A2 A3 B1 VGND VNB VPB VPWR X
.ends

* Black-box entry subcircuit for sky130_fd_sc_hd__nor3_1 abstract view
.subckt sky130_fd_sc_hd__nor3_1 A B C VGND VNB VPB VPWR Y
.ends

.subckt async_fifo VGND VPWR empty full rclk rdata[0] rdata[1] rdata[2] rdata[3] rdata[4]
+ rdata[5] rdata[6] rdata[7] ren rrst_n wclk wdata[0] wdata[1] wdata[2] wdata[3] wdata[4]
+ wdata[5] wdata[6] wdata[7] wen wrst_n
X_501_ net5 bram.mem\[1\]\[2\] _250_ VGND VGND VPWR VPWR _114_ sky130_fd_sc_hd__mux2_1
XFILLER_13_122 VGND VGND VPWR VPWR sky130_fd_sc_hd__decap_6
X_432_ bram.mem\[10\]\[7\] net10 _240_ VGND VGND VPWR VPWR _055_ sky130_fd_sc_hd__mux2_1
X_294_ bram.waddr\[0\] r_ptr_gray_sync\[0\] VGND VGND VPWR VPWR _174_ sky130_fd_sc_hd__xor2_1
X_363_ bram.raddr\[2\] _220_ VGND VGND VPWR VPWR _221_ sky130_fd_sc_hd__or2_1
XFILLER_3_78 VGND VGND VPWR VPWR sky130_fd_sc_hd__decap_4
XFILLER_27_225 VGND VGND VPWR VPWR sky130_fd_sc_hd__decap_3
XTAP_TAPCELL_ROW_20_186 VGND VPWR sky130_fd_sc_hd__tapvpwrvgnd_1
XTAP_TAPCELL_ROW_28_220 VGND VPWR sky130_fd_sc_hd__tapvpwrvgnd_1
XTAP_TAPCELL_ROW_43_289 VGND VPWR sky130_fd_sc_hd__tapvpwrvgnd_1
X_415_ bram.waddr\[0\] bram.waddr\[1\] net23 _234_ VGND VGND VPWR VPWR _239_ sky130_fd_sc_hd__nand4_4
X_346_ bram.mem\[8\]\[0\] bram.mem\[9\]\[0\] bram.mem\[10\]\[0\] bram.mem\[11\]\[0\]
+ bram.raddr\[0\] bram.raddr\[1\] VGND VGND VPWR VPWR _206_ sky130_fd_sc_hd__mux4_1
XTAP_TAPCELL_ROW_11_142 VGND VPWR sky130_fd_sc_hd__tapvpwrvgnd_1
X_277_ bram.mem\[8\]\[6\] bram.mem\[9\]\[6\] bram.mem\[10\]\[6\] bram.mem\[11\]\[6\]
+ bram.raddr\[0\] bram.raddr\[1\] VGND VGND VPWR VPWR _159_ sky130_fd_sc_hd__mux4_1
XTAP_TAPCELL_ROW_34_245 VGND VPWR sky130_fd_sc_hd__tapvpwrvgnd_1
XFILLER_0_57 VGND VGND VPWR VPWR sky130_fd_sc_hd__decap_4
X_329_ _177_ _182_ net11 VGND VGND VPWR VPWR _198_ sky130_fd_sc_hd__a21boi_2
XFILLER_12_209 VPWR VGND VPWR VGND sky130_ef_sc_hd__decap_12
XFILLER_20_253 VGND VGND VPWR VPWR sky130_fd_sc_hd__decap_4
X_680_ clknet_4_3_0_wclk _118_ VGND VGND VPWR VPWR bram.mem\[1\]\[6\] sky130_fd_sc_hd__dfxtp_1
XFILLER_22_7 VGND VGND VPWR VPWR sky130_fd_sc_hd__fill_1
XFILLER_37_194 VGND VGND VPWR VPWR sky130_fd_sc_hd__fill_2
XFILLER_20_65 VGND VGND VPWR VPWR sky130_fd_sc_hd__decap_6
XFILLER_43_153 VGND VGND VPWR VPWR sky130_fd_sc_hd__decap_4
X_594_ clknet_4_8_0_wclk _050_ VGND VGND VPWR VPWR bram.mem\[10\]\[2\] sky130_fd_sc_hd__dfxtp_1
X_663_ clknet_1_0__leaf_rclk u_rptr_handler.g_rptr_next\[1\] net2 VGND VGND VPWR VPWR
+ r_ptr_gray\[1\] sky130_fd_sc_hd__dfrtp_1
XFILLER_43_197 VPWR VGND VPWR VGND sky130_ef_sc_hd__decap_12
XFILLER_13_3 VGND VGND VPWR VPWR sky130_fd_sc_hd__decap_8
XFILLER_26_109 VGND VGND VPWR VPWR sky130_fd_sc_hd__decap_4
XFILLER_34_197 VGND VGND VPWR VPWR sky130_fd_sc_hd__fill_2
XFILLER_17_109 VGND VGND VPWR VPWR sky130_fd_sc_hd__decap_3
XFILLER_15_87 VGND VGND VPWR VPWR sky130_fd_sc_hd__decap_4
XFILLER_31_53 VGND VGND VPWR VPWR sky130_fd_sc_hd__decap_3
Xoutput20 net20 VGND VGND VPWR VPWR rdata[5] sky130_fd_sc_hd__buf_1
XFILLER_31_97 VGND VGND VPWR VPWR sky130_fd_sc_hd__fill_1
X_646_ clknet_4_1_0_wclk _093_ VGND VGND VPWR VPWR bram.mem\[6\]\[5\] sky130_fd_sc_hd__dfxtp_1
XFILLER_16_186 VGND VGND VPWR VPWR sky130_fd_sc_hd__fill_1
XFILLER_16_197 VGND VGND VPWR VPWR sky130_fd_sc_hd__decap_3
X_577_ clknet_4_15_0_wclk _033_ VGND VGND VPWR VPWR bram.mem\[12\]\[1\] sky130_fd_sc_hd__dfxtp_1
XFILLER_39_223 VGND VGND VPWR VPWR sky130_fd_sc_hd__fill_1
XTAP_TAPCELL_ROW_17_170 VGND VPWR sky130_fd_sc_hd__tapvpwrvgnd_1
X_500_ net4 bram.mem\[1\]\[1\] _250_ VGND VGND VPWR VPWR _113_ sky130_fd_sc_hd__mux2_1
X_362_ bram.mem\[8\]\[2\] bram.mem\[9\]\[2\] bram.mem\[10\]\[2\] bram.mem\[11\]\[2\]
+ bram.raddr\[0\] bram.raddr\[1\] VGND VGND VPWR VPWR _220_ sky130_fd_sc_hd__mux4_1
XFILLER_26_64 VGND VGND VPWR VPWR sky130_fd_sc_hd__decap_4
X_431_ bram.mem\[10\]\[6\] net9 _240_ VGND VGND VPWR VPWR _054_ sky130_fd_sc_hd__mux2_1
XFILLER_42_85 VGND VGND VPWR VPWR sky130_fd_sc_hd__decap_6
XFILLER_42_74 VGND VGND VPWR VPWR sky130_fd_sc_hd__decap_8
XFILLER_42_63 VGND VGND VPWR VPWR sky130_fd_sc_hd__fill_2
XFILLER_42_41 VGND VGND VPWR VPWR sky130_fd_sc_hd__decap_6
X_293_ r_ptr_gray_sync\[1\] _172_ VGND VGND VPWR VPWR _173_ sky130_fd_sc_hd__xnor2_1
X_629_ clknet_4_13_0_wclk u_wrptr_handler.g_wptr_next\[0\] net12 VGND VGND VPWR VPWR
+ sync_gwptr_to_rd.d1\[0\] sky130_fd_sc_hd__dfrtp_1
XTAP_TAPCELL_ROW_6_119 VGND VPWR sky130_fd_sc_hd__tapvpwrvgnd_1
XFILLER_27_248 VGND VGND VPWR VPWR sky130_fd_sc_hd__decap_8
XFILLER_12_11 VGND VGND VPWR VPWR sky130_fd_sc_hd__fill_1
XTAP_TAPCELL_ROW_28_221 VGND VPWR sky130_fd_sc_hd__tapvpwrvgnd_1
X_345_ sync_gwptr_to_rd.d1\[4\] _205_ VGND VGND VPWR VPWR u_wrptr_handler.g_wptr_next\[3\]
+ sky130_fd_sc_hd__xor2_1
X_414_ bram.mem\[12\]\[7\] net10 _238_ VGND VGND VPWR VPWR _039_ sky130_fd_sc_hd__mux2_1
XFILLER_33_229 VGND VGND VPWR VPWR sky130_fd_sc_hd__fill_1
X_276_ _136_ _157_ VGND VGND VPWR VPWR _158_ sky130_fd_sc_hd__or2_1
XTAP_TAPCELL_ROW_11_143 VGND VPWR sky130_fd_sc_hd__tapvpwrvgnd_1
XTAP_TAPCELL_ROW_34_246 VGND VPWR sky130_fd_sc_hd__tapvpwrvgnd_1
XPHY_EDGE_ROW_12_Right_12 VGND VGND VPWR VPWR sky130_fd_sc_hd__decap_3
XPHY_EDGE_ROW_21_Right_21 VGND VGND VPWR VPWR sky130_fd_sc_hd__decap_3
XFILLER_23_251 VGND VGND VPWR VPWR sky130_fd_sc_hd__decap_3
XPHY_EDGE_ROW_30_Right_30 VGND VGND VPWR VPWR sky130_fd_sc_hd__decap_3
XFILLER_9_45 VGND VGND VPWR VPWR sky130_fd_sc_hd__fill_2
X_259_ bram.mem\[12\]\[4\] bram.mem\[13\]\[4\] bram.mem\[14\]\[4\] bram.mem\[15\]\[4\]
+ bram.raddr\[0\] bram.raddr\[1\] VGND VGND VPWR VPWR _143_ sky130_fd_sc_hd__mux4_1
X_328_ r_ptr_bin\[4\] _196_ VGND VGND VPWR VPWR u_rptr_handler.g_rptr_next\[3\] sky130_fd_sc_hd__xnor2_1
XFILLER_43_3 VPWR VGND VPWR VGND sky130_ef_sc_hd__decap_12
XTAP_TAPCELL_ROW_0_90 VGND VPWR sky130_fd_sc_hd__tapvpwrvgnd_1
XFILLER_20_221 VGND VGND VPWR VPWR sky130_fd_sc_hd__decap_6
XFILLER_7_225 VPWR VGND VPWR VGND sky130_ef_sc_hd__decap_12
XFILLER_29_129 VGND VGND VPWR VPWR sky130_fd_sc_hd__fill_2
X_662_ clknet_1_1__leaf_rclk u_rptr_handler.g_rptr_next\[0\] net2 VGND VGND VPWR VPWR
+ r_ptr_gray\[0\] sky130_fd_sc_hd__dfrtp_1
X_593_ clknet_4_14_0_wclk _049_ VGND VGND VPWR VPWR bram.mem\[10\]\[1\] sky130_fd_sc_hd__dfxtp_1
XPHY_EDGE_ROW_6_Right_6 VGND VGND VPWR VPWR sky130_fd_sc_hd__decap_3
XFILLER_1_209 VPWR VGND VPWR VGND sky130_ef_sc_hd__decap_12
XFILLER_15_66 VGND VGND VPWR VPWR sky130_fd_sc_hd__fill_1
XFILLER_25_165 VGND VGND VPWR VPWR sky130_fd_sc_hd__decap_3
Xoutput21 net21 VGND VGND VPWR VPWR rdata[6] sky130_fd_sc_hd__buf_1
XFILLER_0_253 VGND VGND VPWR VPWR sky130_fd_sc_hd__decap_4
X_645_ clknet_4_0_0_wclk _092_ VGND VGND VPWR VPWR bram.mem\[6\]\[4\] sky130_fd_sc_hd__dfxtp_1
X_576_ clknet_4_12_0_wclk _032_ VGND VGND VPWR VPWR bram.mem\[12\]\[0\] sky130_fd_sc_hd__dfxtp_1
XTAP_TAPCELL_ROW_17_171 VGND VPWR sky130_fd_sc_hd__tapvpwrvgnd_1
XFILLER_22_102 VPWR VGND VPWR VGND sky130_ef_sc_hd__decap_12
XFILLER_9_139 VGND VGND VPWR VPWR sky130_fd_sc_hd__fill_1
X_292_ r_ptr_gray_sync\[2\] _171_ VGND VGND VPWR VPWR _172_ sky130_fd_sc_hd__xnor2_1
X_430_ bram.mem\[10\]\[5\] net8 _240_ VGND VGND VPWR VPWR _053_ sky130_fd_sc_hd__mux2_1
X_361_ _214_ _216_ _219_ _137_ VGND VGND VPWR VPWR _001_ sky130_fd_sc_hd__a22o_1
XTAP_TAPCELL_ROW_23_196 VGND VPWR sky130_fd_sc_hd__tapvpwrvgnd_1
X_628_ clknet_4_13_0_wclk u_wrptr_handler.b_wptr_next\[4\] net12 VGND VGND VPWR VPWR
+ sync_gwptr_to_rd.d1\[4\] sky130_fd_sc_hd__dfrtp_2
X_559_ clknet_4_13_0_wclk r_ptr_bin\[4\] net12 VGND VGND VPWR VPWR sync_grptr_to_wr.q1\[4\]
+ sky130_fd_sc_hd__dfrtp_1
XFILLER_27_205 VPWR VGND VPWR VGND sky130_ef_sc_hd__decap_12
XPHY_EDGE_ROW_19_Left_63 VGND VGND VPWR VPWR sky130_fd_sc_hd__decap_3
Xclkbuf_0_wclk wclk VGND VGND VPWR VPWR clknet_0_wclk sky130_fd_sc_hd__clkbuf_16
XFILLER_18_249 VGND VGND VPWR VPWR sky130_fd_sc_hd__decap_3
XTAP_TAPCELL_ROW_28_222 VGND VPWR sky130_fd_sc_hd__tapvpwrvgnd_1
X_413_ bram.mem\[12\]\[6\] net9 _238_ VGND VGND VPWR VPWR _038_ sky130_fd_sc_hd__mux2_1
XFILLER_37_97 VPWR VGND VPWR VGND sky130_ef_sc_hd__decap_12
XTAP_TAPCELL_ROW_11_144 VGND VPWR sky130_fd_sc_hd__tapvpwrvgnd_1
X_344_ sync_gwptr_to_rd.d1\[4\] _204_ VGND VGND VPWR VPWR u_wrptr_handler.b_wptr_next\[4\]
+ sky130_fd_sc_hd__xnor2_1
X_275_ bram.mem\[12\]\[6\] bram.mem\[13\]\[6\] bram.mem\[14\]\[6\] bram.mem\[15\]\[6\]
+ bram.raddr\[0\] bram.raddr\[1\] VGND VGND VPWR VPWR _157_ sky130_fd_sc_hd__mux4_1
XTAP_TAPCELL_ROW_34_247 VGND VPWR sky130_fd_sc_hd__tapvpwrvgnd_1
Xclkbuf_4_9_0_wclk clknet_0_wclk VGND VGND VPWR VPWR clknet_4_9_0_wclk sky130_fd_sc_hd__clkbuf_8
XTAP_TAPCELL_ROW_2_101 VGND VPWR sky130_fd_sc_hd__tapvpwrvgnd_1
XPHY_EDGE_ROW_4_Left_48 VGND VGND VPWR VPWR sky130_fd_sc_hd__decap_3
XFILLER_3_3 VPWR VGND VPWR VGND sky130_ef_sc_hd__decap_12
XFILLER_0_15 VPWR VGND VPWR VGND sky130_ef_sc_hd__decap_12
XFILLER_0_37 VGND VGND VPWR VPWR sky130_fd_sc_hd__fill_1
XFILLER_9_57 VGND VGND VPWR VPWR sky130_fd_sc_hd__decap_8
X_258_ sync_gwptr_to_rd.q2\[4\] VGND VGND VPWR VPWR _142_ sky130_fd_sc_hd__inv_2
X_327_ r_ptr_bin\[4\] _197_ VGND VGND VPWR VPWR u_rptr_handler.b_rptr_next\[4\] sky130_fd_sc_hd__xnor2_1
XTAP_TAPCELL_ROW_0_91 VGND VPWR sky130_fd_sc_hd__tapvpwrvgnd_1
XFILLER_36_3 VGND VGND VPWR VPWR sky130_fd_sc_hd__decap_6
XFILLER_34_21 VGND VGND VPWR VPWR sky130_fd_sc_hd__decap_6
XFILLER_7_237 VPWR VGND VPWR VGND sky130_ef_sc_hd__decap_12
XFILLER_11_211 VPWR VGND VPWR VGND sky130_ef_sc_hd__decap_12
X_592_ clknet_4_12_0_wclk _048_ VGND VGND VPWR VPWR bram.mem\[10\]\[0\] sky130_fd_sc_hd__dfxtp_1
X_661_ clknet_1_1__leaf_rclk u_rptr_handler.b_rptr_next\[4\] net2 VGND VGND VPWR VPWR
+ r_ptr_bin\[4\] sky130_fd_sc_hd__dfrtp_4
XPHY_EDGE_ROW_7_Left_51 VGND VGND VPWR VPWR sky130_fd_sc_hd__decap_3
XFILLER_6_69 VGND VGND VPWR VPWR sky130_fd_sc_hd__decap_8
XFILLER_31_22 VGND VGND VPWR VPWR sky130_fd_sc_hd__decap_6
XPHY_EDGE_ROW_33_Left_77 VGND VGND VPWR VPWR sky130_fd_sc_hd__decap_3
Xoutput22 net22 VGND VGND VPWR VPWR rdata[7] sky130_fd_sc_hd__buf_1
XFILLER_0_221 VGND VGND VPWR VPWR sky130_fd_sc_hd__decap_3
X_644_ clknet_4_3_0_wclk _091_ VGND VGND VPWR VPWR bram.mem\[6\]\[3\] sky130_fd_sc_hd__dfxtp_1
X_575_ clknet_4_11_0_wclk _031_ VGND VGND VPWR VPWR bram.mem\[13\]\[7\] sky130_fd_sc_hd__dfxtp_1
XFILLER_31_169 VPWR VGND VPWR VGND sky130_ef_sc_hd__decap_12
XFILLER_39_225 VPWR VGND VPWR VGND sky130_ef_sc_hd__decap_12
XTAP_TAPCELL_ROW_17_172 VGND VPWR sky130_fd_sc_hd__tapvpwrvgnd_1
XFILLER_22_114 VGND VGND VPWR VPWR sky130_fd_sc_hd__decap_6
XFILLER_13_169 VGND VGND VPWR VPWR sky130_fd_sc_hd__decap_4
X_360_ _217_ _218_ bram.raddr\[2\] VGND VGND VPWR VPWR _219_ sky130_fd_sc_hd__mux2_1
XTAP_TAPCELL_ROW_23_197 VGND VPWR sky130_fd_sc_hd__tapvpwrvgnd_1
X_291_ r_ptr_gray_sync\[4\] r_ptr_gray_sync\[3\] VGND VGND VPWR VPWR _171_ sky130_fd_sc_hd__xor2_1
XFILLER_26_99 VGND VGND VPWR VPWR sky130_fd_sc_hd__fill_1
XFILLER_3_15 VPWR VGND VPWR VGND sky130_ef_sc_hd__decap_12
X_627_ clknet_4_13_0_wclk u_wrptr_handler.b_wptr_next\[3\] net12 VGND VGND VPWR VPWR
+ bram.waddr\[3\] sky130_fd_sc_hd__dfrtp_1
X_558_ clknet_4_13_0_wclk r_ptr_gray\[3\] net12 VGND VGND VPWR VPWR sync_grptr_to_wr.q1\[3\]
+ sky130_fd_sc_hd__dfrtp_1
XFILLER_8_195 VGND VGND VPWR VPWR sky130_fd_sc_hd__fill_1
X_489_ bram.waddr\[0\] bram.waddr\[1\] net23 _241_ VGND VGND VPWR VPWR _249_ sky130_fd_sc_hd__and4bb_4
XFILLER_42_209 VPWR VGND VPWR VGND sky130_ef_sc_hd__decap_12
XFILLER_27_217 VGND VGND VPWR VPWR sky130_fd_sc_hd__decap_6
X_412_ bram.mem\[12\]\[5\] net8 _238_ VGND VGND VPWR VPWR _037_ sky130_fd_sc_hd__mux2_1
XFILLER_37_54 VGND VGND VPWR VPWR sky130_fd_sc_hd__fill_2
XTAP_TAPCELL_ROW_11_145 VGND VPWR sky130_fd_sc_hd__tapvpwrvgnd_1
X_343_ _138_ _202_ VGND VGND VPWR VPWR u_wrptr_handler.g_wptr_next\[2\] sky130_fd_sc_hd__xnor2_1
X_274_ _151_ _153_ _156_ _137_ VGND VGND VPWR VPWR _005_ sky130_fd_sc_hd__a22o_1
XPHY_EDGE_ROW_36_Left_80 VGND VGND VPWR VPWR sky130_fd_sc_hd__decap_3
XPHY_EDGE_ROW_20_Left_64 VGND VGND VPWR VPWR sky130_fd_sc_hd__decap_3
XTAP_TAPCELL_ROW_42_281 VGND VPWR sky130_fd_sc_hd__tapvpwrvgnd_1
XTAP_TAPCELL_ROW_34_248 VGND VPWR sky130_fd_sc_hd__tapvpwrvgnd_1
XTAP_TAPCELL_ROW_2_102 VGND VPWR sky130_fd_sc_hd__tapvpwrvgnd_1
XFILLER_23_23 VGND VGND VPWR VPWR sky130_fd_sc_hd__fill_2
XFILLER_0_27 VGND VGND VPWR VPWR sky130_fd_sc_hd__fill_1
XFILLER_14_253 VGND VGND VPWR VPWR sky130_fd_sc_hd__fill_1
X_326_ bram.raddr\[3\] _195_ VGND VGND VPWR VPWR u_rptr_handler.g_rptr_next\[2\] sky130_fd_sc_hd__xnor2_1
X_257_ r_ptr_gray\[3\] VGND VGND VPWR VPWR _141_ sky130_fd_sc_hd__inv_2
XTAP_TAPCELL_ROW_0_92 VGND VPWR sky130_fd_sc_hd__tapvpwrvgnd_1
XFILLER_29_3 VPWR VGND VPWR VGND sky130_ef_sc_hd__decap_12
XFILLER_11_223 VGND VGND VPWR VPWR sky130_fd_sc_hd__fill_1
XFILLER_34_33 VGND VGND VPWR VPWR sky130_fd_sc_hd__fill_1
XFILLER_7_249 VGND VGND VPWR VPWR sky130_fd_sc_hd__decap_8
XFILLER_11_245 VGND VGND VPWR VPWR sky130_fd_sc_hd__fill_1
X_309_ sync_gwptr_to_rd.q2\[2\] _140_ _142_ r_ptr_bin\[4\] _183_ VGND VGND VPWR VPWR
+ _188_ sky130_fd_sc_hd__a221o_1
XFILLER_20_46 VGND VGND VPWR VPWR sky130_fd_sc_hd__decap_3
XFILLER_28_131 VGND VGND VPWR VPWR sky130_fd_sc_hd__decap_8
XFILLER_28_175 VGND VGND VPWR VPWR sky130_fd_sc_hd__decap_6
XFILLER_28_197 VGND VGND VPWR VPWR sky130_fd_sc_hd__decap_6
XFILLER_29_55 VGND VGND VPWR VPWR sky130_fd_sc_hd__fill_1
XFILLER_29_66 VGND VGND VPWR VPWR sky130_fd_sc_hd__fill_2
XFILLER_29_88 VGND VGND VPWR VPWR sky130_fd_sc_hd__fill_1
X_591_ clknet_4_10_0_wclk _047_ VGND VGND VPWR VPWR bram.mem\[11\]\[7\] sky130_fd_sc_hd__dfxtp_1
X_660_ clknet_1_1__leaf_rclk u_rptr_handler.b_rptr_next\[3\] net2 VGND VGND VPWR VPWR
+ bram.raddr\[3\] sky130_fd_sc_hd__dfrtp_4
XFILLER_43_167 VGND VGND VPWR VPWR sky130_fd_sc_hd__fill_1
XFILLER_6_15 VPWR VGND VPWR VGND sky130_ef_sc_hd__decap_12
XFILLER_25_123 VGND VGND VPWR VPWR sky130_fd_sc_hd__fill_2
XFILLER_15_35 VGND VGND VPWR VPWR sky130_fd_sc_hd__fill_1
XFILLER_40_137 VGND VGND VPWR VPWR sky130_fd_sc_hd__decap_3
XFILLER_31_45 VGND VGND VPWR VPWR sky130_fd_sc_hd__decap_8
XFILLER_31_89 VGND VGND VPWR VPWR sky130_fd_sc_hd__decap_8
X_643_ clknet_4_0_0_wclk _090_ VGND VGND VPWR VPWR bram.mem\[6\]\[2\] sky130_fd_sc_hd__dfxtp_1
XFILLER_16_178 VGND VGND VPWR VPWR sky130_fd_sc_hd__decap_8
X_574_ clknet_4_11_0_wclk _030_ VGND VGND VPWR VPWR bram.mem\[13\]\[6\] sky130_fd_sc_hd__dfxtp_1
XFILLER_31_137 VGND VGND VPWR VPWR sky130_fd_sc_hd__fill_2
XFILLER_31_148 VPWR VGND VPWR VGND sky130_ef_sc_hd__decap_12
XFILLER_11_3 VGND VGND VPWR VPWR sky130_fd_sc_hd__decap_6
XFILLER_39_237 VPWR VGND VPWR VGND sky130_ef_sc_hd__decap_12
XFILLER_21_181 VGND VGND VPWR VPWR sky130_fd_sc_hd__fill_1
XTAP_TAPCELL_ROW_23_198 VGND VPWR sky130_fd_sc_hd__tapvpwrvgnd_1
X_290_ _165_ _167_ _170_ _137_ VGND VGND VPWR VPWR _007_ sky130_fd_sc_hd__a22o_1
XTAP_TAPCELL_ROW_8_130 VGND VPWR sky130_fd_sc_hd__tapvpwrvgnd_1
XFILLER_3_27 VPWR VGND VPWR VGND sky130_ef_sc_hd__decap_12
X_488_ net10 bram.mem\[3\]\[7\] _248_ VGND VGND VPWR VPWR _103_ sky130_fd_sc_hd__mux2_1
X_626_ clknet_4_7_0_wclk u_wrptr_handler.b_wptr_next\[2\] net12 VGND VGND VPWR VPWR
+ bram.waddr\[2\] sky130_fd_sc_hd__dfrtp_4
X_557_ clknet_4_7_0_wclk r_ptr_gray\[2\] net12 VGND VGND VPWR VPWR sync_grptr_to_wr.q1\[2\]
+ sky130_fd_sc_hd__dfrtp_1
XFILLER_8_152 VGND VGND VPWR VPWR sky130_fd_sc_hd__decap_4
XFILLER_12_192 VGND VGND VPWR VPWR sky130_fd_sc_hd__decap_4
X_342_ _204_ _205_ VGND VGND VPWR VPWR u_wrptr_handler.b_wptr_next\[3\] sky130_fd_sc_hd__and2_1
X_411_ bram.mem\[12\]\[4\] net7 _238_ VGND VGND VPWR VPWR _036_ sky130_fd_sc_hd__mux2_1
XFILLER_37_77 VGND VGND VPWR VPWR sky130_fd_sc_hd__fill_1
XFILLER_41_210 VGND VGND VPWR VPWR sky130_fd_sc_hd__fill_1
X_273_ _154_ _155_ bram.raddr\[2\] VGND VGND VPWR VPWR _156_ sky130_fd_sc_hd__mux2_1
XFILLER_5_111 VGND VGND VPWR VPWR sky130_fd_sc_hd__fill_1
X_609_ clknet_4_15_0_wclk _065_ VGND VGND VPWR VPWR bram.mem\[8\]\[1\] sky130_fd_sc_hd__dfxtp_1
XTAP_TAPCELL_ROW_42_282 VGND VPWR sky130_fd_sc_hd__tapvpwrvgnd_1
XTAP_TAPCELL_ROW_34_249 VGND VPWR sky130_fd_sc_hd__tapvpwrvgnd_1
XTAP_TAPCELL_ROW_2_103 VGND VPWR sky130_fd_sc_hd__tapvpwrvgnd_1
XTAP_TAPCELL_ROW_25_205 VGND VPWR sky130_fd_sc_hd__tapvpwrvgnd_1
XFILLER_23_46 VGND VGND VPWR VPWR sky130_fd_sc_hd__fill_1
XFILLER_23_57 VGND VGND VPWR VPWR sky130_fd_sc_hd__decap_6
XFILLER_9_37 VGND VGND VPWR VPWR sky130_fd_sc_hd__decap_8
XFILLER_9_15 VPWR VGND VPWR VGND sky130_ef_sc_hd__decap_12
X_325_ _196_ _197_ VGND VGND VPWR VPWR u_rptr_handler.b_rptr_next\[3\] sky130_fd_sc_hd__and2b_1
X_256_ r_ptr_gray\[2\] VGND VGND VPWR VPWR _140_ sky130_fd_sc_hd__inv_2
XTAP_TAPCELL_ROW_0_93 VGND VPWR sky130_fd_sc_hd__tapvpwrvgnd_1
XTAP_TAPCELL_ROW_30_230 VGND VPWR sky130_fd_sc_hd__tapvpwrvgnd_1
Xclkload0 clknet_4_0_0_wclk VGND VGND VPWR VPWR clkload0/X sky130_fd_sc_hd__clkbuf_8
X_308_ sync_gwptr_to_rd.q2\[2\] _140_ _142_ r_ptr_bin\[4\] _184_ VGND VGND VPWR VPWR
+ _187_ sky130_fd_sc_hd__o221ai_2
XFILLER_41_3 VPWR VGND VPWR VGND sky130_ef_sc_hd__decap_12
XFILLER_4_209 VPWR VGND VPWR VGND sky130_ef_sc_hd__decap_12
XFILLER_43_146 VGND VGND VPWR VPWR sky130_fd_sc_hd__decap_4
XFILLER_43_113 VGND VGND VPWR VPWR sky130_fd_sc_hd__fill_2
X_590_ clknet_4_11_0_wclk _046_ VGND VGND VPWR VPWR bram.mem\[11\]\[6\] sky130_fd_sc_hd__dfxtp_1
XFILLER_6_27 VGND VGND VPWR VPWR sky130_fd_sc_hd__fill_1
XFILLER_19_165 VGND VGND VPWR VPWR sky130_fd_sc_hd__decap_3
XFILLER_25_113 VGND VGND VPWR VPWR sky130_fd_sc_hd__decap_3
Xoutput13 net13 VGND VGND VPWR VPWR empty sky130_fd_sc_hd__buf_1
XFILLER_31_57 VGND VGND VPWR VPWR sky130_fd_sc_hd__decap_6
X_642_ clknet_4_4_0_wclk _089_ VGND VGND VPWR VPWR bram.mem\[6\]\[1\] sky130_fd_sc_hd__dfxtp_1
XFILLER_16_168 VGND VGND VPWR VPWR sky130_fd_sc_hd__fill_1
XPHY_EDGE_ROW_19_Right_19 VGND VGND VPWR VPWR sky130_fd_sc_hd__decap_3
X_573_ clknet_4_9_0_wclk _029_ VGND VGND VPWR VPWR bram.mem\[13\]\[5\] sky130_fd_sc_hd__dfxtp_1
XPHY_EDGE_ROW_28_Right_28 VGND VGND VPWR VPWR sky130_fd_sc_hd__decap_3
XPHY_EDGE_ROW_37_Right_37 VGND VGND VPWR VPWR sky130_fd_sc_hd__decap_3
XFILLER_39_249 VGND VGND VPWR VPWR sky130_fd_sc_hd__decap_8
XFILLER_26_79 VGND VGND VPWR VPWR sky130_fd_sc_hd__decap_4
XTAP_TAPCELL_ROW_23_199 VGND VPWR sky130_fd_sc_hd__tapvpwrvgnd_1
XTAP_TAPCELL_ROW_8_131 VGND VPWR sky130_fd_sc_hd__tapvpwrvgnd_1
XFILLER_3_39 VGND VGND VPWR VPWR sky130_fd_sc_hd__decap_8
X_625_ clknet_4_6_0_wclk u_wrptr_handler.b_wptr_next\[1\] net12 VGND VGND VPWR VPWR
+ bram.waddr\[1\] sky130_fd_sc_hd__dfrtp_4
XTAP_TAPCELL_ROW_14_155 VGND VPWR sky130_fd_sc_hd__tapvpwrvgnd_1
X_487_ net9 bram.mem\[3\]\[6\] _248_ VGND VGND VPWR VPWR _102_ sky130_fd_sc_hd__mux2_1
X_556_ clknet_4_7_0_wclk r_ptr_gray\[1\] net12 VGND VGND VPWR VPWR sync_grptr_to_wr.q1\[1\]
+ sky130_fd_sc_hd__dfrtp_1
XFILLER_8_197 VPWR VGND VPWR VGND sky130_ef_sc_hd__decap_12
X_272_ bram.mem\[4\]\[5\] bram.mem\[5\]\[5\] bram.mem\[6\]\[5\] bram.mem\[7\]\[5\]
+ bram.raddr\[0\] bram.raddr\[1\] VGND VGND VPWR VPWR _155_ sky130_fd_sc_hd__mux4_1
X_341_ bram.waddr\[0\] bram.waddr\[1\] bram.waddr\[2\] net23 bram.waddr\[3\] VGND
+ VGND VPWR VPWR _205_ sky130_fd_sc_hd__a41o_1
X_410_ bram.mem\[12\]\[3\] net6 _238_ VGND VGND VPWR VPWR _035_ sky130_fd_sc_hd__mux2_1
XFILLER_5_167 VGND VGND VPWR VPWR sky130_fd_sc_hd__fill_1
X_608_ clknet_4_12_0_wclk _064_ VGND VGND VPWR VPWR bram.mem\[8\]\[0\] sky130_fd_sc_hd__dfxtp_1
XTAP_TAPCELL_ROW_42_283 VGND VPWR sky130_fd_sc_hd__tapvpwrvgnd_1
X_539_ clknet_1_1__leaf_rclk sync_gwptr_to_rd.d1\[2\] net2 VGND VGND VPWR VPWR sync_gwptr_to_rd.q1\[2\]
+ sky130_fd_sc_hd__dfrtp_1
XTAP_TAPCELL_ROW_2_104 VGND VPWR sky130_fd_sc_hd__tapvpwrvgnd_1
XTAP_TAPCELL_ROW_25_206 VGND VPWR sky130_fd_sc_hd__tapvpwrvgnd_1
XFILLER_0_29 VGND VGND VPWR VPWR sky130_fd_sc_hd__fill_2
XFILLER_9_27 VGND VGND VPWR VPWR sky130_fd_sc_hd__fill_1
X_255_ r_ptr_gray\[0\] VGND VGND VPWR VPWR _139_ sky130_fd_sc_hd__inv_2
X_324_ bram.raddr\[3\] _194_ VGND VGND VPWR VPWR _197_ sky130_fd_sc_hd__nand2_1
XTAP_TAPCELL_ROW_0_94 VGND VPWR sky130_fd_sc_hd__tapvpwrvgnd_1
XTAP_TAPCELL_ROW_30_231 VGND VPWR sky130_fd_sc_hd__tapvpwrvgnd_1
Xclkload1 clknet_4_1_0_wclk VGND VGND VPWR VPWR clkload1/Y sky130_fd_sc_hd__clkinv_2
XFILLER_11_225 VPWR VGND VPWR VGND sky130_ef_sc_hd__decap_12
XFILLER_1_3 VPWR VGND VPWR VGND sky130_ef_sc_hd__decap_12
XFILLER_6_251 VGND VGND VPWR VPWR sky130_fd_sc_hd__fill_1
X_307_ sync_gwptr_to_rd.q2\[0\] _139_ sync_gwptr_to_rd.q2\[3\] _141_ _185_ VGND VGND
+ VPWR VPWR _186_ sky130_fd_sc_hd__a221o_1
XFILLER_20_15 VPWR VGND VPWR VGND sky130_ef_sc_hd__decap_12
XFILLER_43_169 VGND VGND VPWR VPWR sky130_fd_sc_hd__fill_2
XFILLER_10_70 VPWR VGND VPWR VGND sky130_ef_sc_hd__decap_12
XFILLER_15_15 VPWR VGND VPWR VGND sky130_ef_sc_hd__decap_12
XFILLER_25_169 VGND VGND VPWR VPWR sky130_fd_sc_hd__decap_6
Xoutput14 net14 VGND VGND VPWR VPWR full sky130_fd_sc_hd__buf_1
X_641_ clknet_4_4_0_wclk _088_ VGND VGND VPWR VPWR bram.mem\[6\]\[0\] sky130_fd_sc_hd__dfxtp_1
X_572_ clknet_4_14_0_wclk _028_ VGND VGND VPWR VPWR bram.mem\[13\]\[4\] sky130_fd_sc_hd__dfxtp_1
XFILLER_26_25 VGND VGND VPWR VPWR sky130_fd_sc_hd__decap_3
XTAP_TAPCELL_ROW_8_132 VGND VPWR sky130_fd_sc_hd__tapvpwrvgnd_1
X_555_ clknet_4_7_0_wclk r_ptr_gray\[0\] net12 VGND VGND VPWR VPWR sync_grptr_to_wr.q1\[0\]
+ sky130_fd_sc_hd__dfrtp_1
X_624_ clknet_4_7_0_wclk u_wrptr_handler.b_wptr_next\[0\] net12 VGND VGND VPWR VPWR
+ bram.waddr\[0\] sky130_fd_sc_hd__dfrtp_4
XFILLER_29_250 VGND VGND VPWR VPWR sky130_fd_sc_hd__decap_6
X_486_ net8 bram.mem\[3\]\[5\] _248_ VGND VGND VPWR VPWR _101_ sky130_fd_sc_hd__mux2_1
XTAP_TAPCELL_ROW_14_156 VGND VPWR sky130_fd_sc_hd__tapvpwrvgnd_1
XFILLER_8_187 VGND VGND VPWR VPWR sky130_fd_sc_hd__decap_8
XTAP_TAPCELL_ROW_37_259 VGND VPWR sky130_fd_sc_hd__tapvpwrvgnd_1
Xclkbuf_4_4_0_wclk clknet_0_wclk VGND VGND VPWR VPWR clknet_4_4_0_wclk sky130_fd_sc_hd__clkbuf_8
XFILLER_26_231 VGND VGND VPWR VPWR sky130_fd_sc_hd__fill_1
XFILLER_26_253 VGND VGND VPWR VPWR sky130_fd_sc_hd__decap_4
XFILLER_37_57 VPWR VGND VPWR VGND sky130_ef_sc_hd__decap_12
X_271_ bram.mem\[0\]\[5\] bram.mem\[1\]\[5\] bram.mem\[2\]\[5\] bram.mem\[3\]\[5\]
+ bram.raddr\[0\] bram.raddr\[1\] VGND VGND VPWR VPWR _154_ sky130_fd_sc_hd__mux4_1
X_340_ bram.waddr\[0\] bram.waddr\[1\] net23 _203_ VGND VGND VPWR VPWR _204_ sky130_fd_sc_hd__nand4_4
XFILLER_5_113 VPWR VGND VPWR VGND sky130_ef_sc_hd__decap_12
X_607_ clknet_4_2_0_wclk _063_ VGND VGND VPWR VPWR bram.mem\[7\]\[7\] sky130_fd_sc_hd__dfxtp_1
X_538_ clknet_1_1__leaf_rclk sync_gwptr_to_rd.d1\[1\] net2 VGND VGND VPWR VPWR sync_gwptr_to_rd.q1\[1\]
+ sky130_fd_sc_hd__dfrtp_1
XTAP_TAPCELL_ROW_42_284 VGND VPWR sky130_fd_sc_hd__tapvpwrvgnd_1
X_469_ net9 bram.mem\[5\]\[6\] _246_ VGND VGND VPWR VPWR _086_ sky130_fd_sc_hd__mux2_1
XFILLER_4_190 VGND VGND VPWR VPWR sky130_fd_sc_hd__decap_6
XFILLER_4_72 VPWR VGND VPWR VGND sky130_ef_sc_hd__decap_12
XTAP_TAPCELL_ROW_2_105 VGND VPWR sky130_fd_sc_hd__tapvpwrvgnd_1
Xclkbuf_4_12_0_wclk clknet_0_wclk VGND VGND VPWR VPWR clknet_4_12_0_wclk sky130_fd_sc_hd__clkbuf_8
XTAP_TAPCELL_ROW_25_207 VGND VPWR sky130_fd_sc_hd__tapvpwrvgnd_1
XFILLER_14_201 VGND VGND VPWR VPWR sky130_fd_sc_hd__decap_6
X_254_ bram.waddr\[3\] VGND VGND VPWR VPWR _138_ sky130_fd_sc_hd__inv_2
X_323_ bram.raddr\[3\] _194_ VGND VGND VPWR VPWR _196_ sky130_fd_sc_hd__nor2_1
XPHY_EDGE_ROW_24_Left_68 VGND VGND VPWR VPWR sky130_fd_sc_hd__decap_3
XTAP_TAPCELL_ROW_0_95 VGND VPWR sky130_fd_sc_hd__tapvpwrvgnd_1
XFILLER_20_248 VGND VGND VPWR VPWR sky130_fd_sc_hd__decap_4
XFILLER_11_237 VGND VGND VPWR VPWR sky130_fd_sc_hd__decap_8
Xclkload2 clknet_4_2_0_wclk VGND VGND VPWR VPWR clkload2/X sky130_fd_sc_hd__clkbuf_8
X_306_ sync_gwptr_to_rd.q2\[1\] r_ptr_gray\[1\] VGND VGND VPWR VPWR _185_ sky130_fd_sc_hd__xor2_1
XFILLER_27_3 VGND VGND VPWR VPWR sky130_fd_sc_hd__decap_6
XFILLER_20_27 VGND VGND VPWR VPWR sky130_fd_sc_hd__fill_1
XFILLER_20_38 VGND VGND VPWR VPWR sky130_fd_sc_hd__decap_8
XFILLER_43_137 VGND VGND VPWR VPWR sky130_fd_sc_hd__decap_3
XFILLER_6_29 VGND VGND VPWR VPWR sky130_fd_sc_hd__decap_4
XFILLER_10_82 VGND VGND VPWR VPWR sky130_fd_sc_hd__fill_2
XFILLER_3_222 VGND VGND VPWR VPWR sky130_fd_sc_hd__fill_2
XFILLER_19_91 VGND VGND VPWR VPWR sky130_fd_sc_hd__decap_8
XPHY_EDGE_ROW_27_Left_71 VGND VGND VPWR VPWR sky130_fd_sc_hd__decap_3
XPHY_EDGE_ROW_11_Left_55 VGND VGND VPWR VPWR sky130_fd_sc_hd__decap_3
XFILLER_15_27 VGND VGND VPWR VPWR sky130_fd_sc_hd__decap_8
XFILLER_40_118 VGND VGND VPWR VPWR sky130_fd_sc_hd__decap_3
XFILLER_0_225 VPWR VGND VPWR VGND sky130_ef_sc_hd__decap_12
XPHY_EDGE_ROW_1_Right_1 VGND VGND VPWR VPWR sky130_fd_sc_hd__decap_3
Xoutput15 net15 VGND VGND VPWR VPWR rdata[0] sky130_fd_sc_hd__buf_1
X_640_ clknet_4_2_0_wclk _087_ VGND VGND VPWR VPWR bram.mem\[5\]\[7\] sky130_fd_sc_hd__dfxtp_1
X_571_ clknet_4_14_0_wclk _027_ VGND VGND VPWR VPWR bram.mem\[13\]\[3\] sky130_fd_sc_hd__dfxtp_1
XFILLER_31_107 VGND VGND VPWR VPWR sky130_fd_sc_hd__decap_4
XFILLER_31_129 VGND VGND VPWR VPWR sky130_fd_sc_hd__decap_8
XFILLER_21_81 VGND VGND VPWR VPWR sky130_fd_sc_hd__decap_8
XFILLER_30_195 VGND VGND VPWR VPWR sky130_fd_sc_hd__fill_1
X_485_ net7 bram.mem\[3\]\[4\] _248_ VGND VGND VPWR VPWR _100_ sky130_fd_sc_hd__mux2_1
X_623_ clknet_4_3_0_wclk _079_ VGND VGND VPWR VPWR bram.mem\[0\]\[7\] sky130_fd_sc_hd__dfxtp_1
X_554_ clknet_4_13_0_wclk sync_grptr_to_wr.q1\[4\] net12 VGND VGND VPWR VPWR r_ptr_gray_sync\[4\]
+ sky130_fd_sc_hd__dfrtp_1
XTAP_TAPCELL_ROW_14_157 VGND VPWR sky130_fd_sc_hd__tapvpwrvgnd_1
XFILLER_37_69 VGND VGND VPWR VPWR sky130_fd_sc_hd__decap_3
X_270_ _136_ _152_ bram.raddr\[3\] VGND VGND VPWR VPWR _153_ sky130_fd_sc_hd__o21a_1
XFILLER_5_169 VPWR VGND VPWR VGND sky130_ef_sc_hd__decap_12
XFILLER_5_125 VPWR VGND VPWR VGND sky130_ef_sc_hd__decap_12
XFILLER_17_221 VGND VGND VPWR VPWR sky130_fd_sc_hd__decap_3
X_468_ net8 bram.mem\[5\]\[5\] _246_ VGND VGND VPWR VPWR _085_ sky130_fd_sc_hd__mux2_1
X_606_ clknet_4_2_0_wclk _062_ VGND VGND VPWR VPWR bram.mem\[7\]\[6\] sky130_fd_sc_hd__dfxtp_1
X_537_ clknet_1_1__leaf_rclk sync_gwptr_to_rd.d1\[0\] net2 VGND VGND VPWR VPWR sync_gwptr_to_rd.q1\[0\]
+ sky130_fd_sc_hd__dfrtp_1
XTAP_TAPCELL_ROW_42_285 VGND VPWR sky130_fd_sc_hd__tapvpwrvgnd_1
X_399_ net4 bram.mem\[13\]\[1\] _237_ VGND VGND VPWR VPWR _025_ sky130_fd_sc_hd__mux2_1
XFILLER_4_62 VGND VGND VPWR VPWR sky130_fd_sc_hd__fill_1
XFILLER_23_202 VGND VGND VPWR VPWR sky130_fd_sc_hd__fill_2
XTAP_TAPCELL_ROW_25_208 VGND VPWR sky130_fd_sc_hd__tapvpwrvgnd_1
XTAP_TAPCELL_ROW_33_241 VGND VPWR sky130_fd_sc_hd__tapvpwrvgnd_1
X_322_ bram.raddr\[2\] _193_ VGND VGND VPWR VPWR u_rptr_handler.g_rptr_next\[1\] sky130_fd_sc_hd__xnor2_1
X_253_ bram.raddr\[3\] VGND VGND VPWR VPWR _137_ sky130_fd_sc_hd__inv_2
XTAP_TAPCELL_ROW_0_96 VGND VPWR sky130_fd_sc_hd__tapvpwrvgnd_1
XFILLER_20_227 VGND VGND VPWR VPWR sky130_fd_sc_hd__fill_1
XPHY_EDGE_ROW_41_Left_85 VGND VGND VPWR VPWR sky130_fd_sc_hd__decap_3
XFILLER_7_209 VPWR VGND VPWR VGND sky130_ef_sc_hd__decap_12
Xclkload3 clknet_4_3_0_wclk VGND VGND VPWR VPWR clkload3/Y sky130_fd_sc_hd__bufinv_16
X_305_ sync_gwptr_to_rd.q2\[0\] r_ptr_gray\[0\] VGND VGND VPWR VPWR _184_ sky130_fd_sc_hd__nand2b_1
XFILLER_6_253 VGND VGND VPWR VPWR sky130_fd_sc_hd__decap_4
XFILLER_29_15 VPWR VGND VPWR VGND sky130_ef_sc_hd__decap_12
XFILLER_28_157 VGND VGND VPWR VPWR sky130_fd_sc_hd__fill_2
XFILLER_10_94 VGND VGND VPWR VPWR sky130_fd_sc_hd__decap_8
XFILLER_19_113 VGND VGND VPWR VPWR sky130_fd_sc_hd__fill_1
XFILLER_19_146 VGND VGND VPWR VPWR sky130_fd_sc_hd__decap_6
XFILLER_42_193 VGND VGND VPWR VPWR sky130_fd_sc_hd__decap_3
Xoutput16 net16 VGND VGND VPWR VPWR rdata[1] sky130_fd_sc_hd__buf_1
XFILLER_0_237 VPWR VGND VPWR VGND sky130_ef_sc_hd__decap_12
X_570_ clknet_4_9_0_wclk _026_ VGND VGND VPWR VPWR bram.mem\[13\]\[2\] sky130_fd_sc_hd__dfxtp_1
XFILLER_39_219 VGND VGND VPWR VPWR sky130_fd_sc_hd__decap_4
XFILLER_15_160 VGND VGND VPWR VPWR sky130_fd_sc_hd__fill_1
XFILLER_7_95 VGND VGND VPWR VPWR sky130_fd_sc_hd__fill_1
XFILLER_30_141 VGND VGND VPWR VPWR sky130_fd_sc_hd__fill_2
XPHY_EDGE_ROW_15_Right_15 VGND VGND VPWR VPWR sky130_fd_sc_hd__decap_3
XPHY_EDGE_ROW_24_Right_24 VGND VGND VPWR VPWR sky130_fd_sc_hd__decap_3
XFILLER_38_241 VGND VGND VPWR VPWR sky130_fd_sc_hd__decap_8
XFILLER_42_15 VPWR VGND VPWR VGND sky130_ef_sc_hd__decap_12
XPHY_EDGE_ROW_33_Right_33 VGND VGND VPWR VPWR sky130_fd_sc_hd__decap_3
X_622_ clknet_4_3_0_wclk _078_ VGND VGND VPWR VPWR bram.mem\[0\]\[6\] sky130_fd_sc_hd__dfxtp_1
XPHY_EDGE_ROW_42_Right_42 VGND VGND VPWR VPWR sky130_fd_sc_hd__decap_3
X_484_ net6 bram.mem\[3\]\[3\] _248_ VGND VGND VPWR VPWR _099_ sky130_fd_sc_hd__mux2_1
X_553_ clknet_4_13_0_wclk sync_grptr_to_wr.q1\[3\] net12 VGND VGND VPWR VPWR r_ptr_gray_sync\[3\]
+ sky130_fd_sc_hd__dfrtp_1
XFILLER_8_156 VGND VGND VPWR VPWR sky130_fd_sc_hd__fill_1
XTAP_TAPCELL_ROW_14_158 VGND VPWR sky130_fd_sc_hd__tapvpwrvgnd_1
XTAP_TAPCELL_ROW_22_191 VGND VPWR sky130_fd_sc_hd__tapvpwrvgnd_1
XFILLER_12_29 VGND VGND VPWR VPWR sky130_fd_sc_hd__decap_6
XTAP_TAPCELL_ROW_5_115 VGND VPWR sky130_fd_sc_hd__tapvpwrvgnd_1
XFILLER_41_225 VPWR VGND VPWR VGND sky130_ef_sc_hd__decap_12
XFILLER_5_137 VPWR VGND VPWR VGND sky130_ef_sc_hd__decap_12
X_605_ clknet_4_1_0_wclk _061_ VGND VGND VPWR VPWR bram.mem\[7\]\[5\] sky130_fd_sc_hd__dfxtp_1
XFILLER_17_255 VGND VGND VPWR VPWR sky130_fd_sc_hd__fill_2
X_467_ net7 bram.mem\[5\]\[4\] _246_ VGND VGND VPWR VPWR _084_ sky130_fd_sc_hd__mux2_1
XFILLER_27_92 VPWR VGND VPWR VGND sky130_ef_sc_hd__decap_12
X_398_ net3 bram.mem\[13\]\[0\] _237_ VGND VGND VPWR VPWR _024_ sky130_fd_sc_hd__mux2_1
X_536_ clknet_1_1__leaf_rclk sync_gwptr_to_rd.q1\[4\] net2 VGND VGND VPWR VPWR sync_gwptr_to_rd.q2\[4\]
+ sky130_fd_sc_hd__dfrtp_1
XFILLER_4_85 VPWR VGND VPWR VGND sky130_ef_sc_hd__decap_12
XFILLER_4_41 VGND VGND VPWR VPWR sky130_fd_sc_hd__decap_8
XFILLER_23_225 VPWR VGND VPWR VGND sky130_ef_sc_hd__decap_12
XTAP_TAPCELL_ROW_33_242 VGND VPWR sky130_fd_sc_hd__tapvpwrvgnd_1
X_252_ bram.raddr\[2\] VGND VGND VPWR VPWR _136_ sky130_fd_sc_hd__inv_2
X_321_ _194_ _195_ VGND VGND VPWR VPWR u_rptr_handler.b_rptr_next\[2\] sky130_fd_sc_hd__nor2_1
XFILLER_13_94 VGND VGND VPWR VPWR sky130_fd_sc_hd__fill_2
X_519_ bram.mem\[2\]\[3\] net6 _251_ VGND VGND VPWR VPWR _131_ sky130_fd_sc_hd__mux2_1
Xclkload10 clknet_4_11_0_wclk VGND VGND VPWR VPWR clkload10/Y sky130_fd_sc_hd__clkinv_2
XFILLER_34_27 VGND VGND VPWR VPWR sky130_fd_sc_hd__fill_1
Xclkload4 clknet_4_4_0_wclk VGND VGND VPWR VPWR clkload4/Y sky130_fd_sc_hd__bufinv_16
X_304_ sync_gwptr_to_rd.q2\[3\] r_ptr_gray\[3\] VGND VGND VPWR VPWR _183_ sky130_fd_sc_hd__and2b_1
XFILLER_6_221 VPWR VGND VPWR VGND sky130_ef_sc_hd__decap_12
XFILLER_40_81 VGND VGND VPWR VPWR sky130_fd_sc_hd__decap_3
XFILLER_37_136 VPWR VGND VPWR VGND sky130_ef_sc_hd__decap_12
XFILLER_37_169 VGND VGND VPWR VPWR sky130_fd_sc_hd__fill_2
XFILLER_29_27 VPWR VGND VPWR VGND sky130_ef_sc_hd__decap_12
XFILLER_3_202 VPWR VGND VPWR VGND sky130_ef_sc_hd__decap_12
Xoutput17 net17 VGND VGND VPWR VPWR rdata[2] sky130_fd_sc_hd__buf_1
XFILLER_31_28 VGND VGND VPWR VPWR sky130_fd_sc_hd__fill_1
XFILLER_0_249 VGND VGND VPWR VPWR sky130_fd_sc_hd__decap_3
XFILLER_16_117 VGND VGND VPWR VPWR sky130_fd_sc_hd__fill_2
XFILLER_16_128 VPWR VGND VPWR VGND sky130_ef_sc_hd__decap_12
XFILLER_38_220 VGND VGND VPWR VPWR sky130_fd_sc_hd__fill_1
XFILLER_38_253 VGND VGND VPWR VPWR sky130_fd_sc_hd__decap_4
XFILLER_42_27 VGND VGND VPWR VPWR sky130_fd_sc_hd__fill_1
X_621_ clknet_4_4_0_wclk _077_ VGND VGND VPWR VPWR bram.mem\[0\]\[5\] sky130_fd_sc_hd__dfxtp_1
XTAP_TAPCELL_ROW_39_270 VGND VPWR sky130_fd_sc_hd__tapvpwrvgnd_1
X_483_ net5 bram.mem\[3\]\[2\] _248_ VGND VGND VPWR VPWR _098_ sky130_fd_sc_hd__mux2_1
XTAP_TAPCELL_ROW_14_159 VGND VPWR sky130_fd_sc_hd__tapvpwrvgnd_1
XFILLER_16_83 VGND VGND VPWR VPWR sky130_fd_sc_hd__fill_1
X_552_ clknet_4_7_0_wclk sync_grptr_to_wr.q1\[2\] net12 VGND VGND VPWR VPWR r_ptr_gray_sync\[2\]
+ sky130_fd_sc_hd__dfrtp_1
XFILLER_12_197 VPWR VGND VPWR VGND sky130_ef_sc_hd__decap_12
XTAP_TAPCELL_ROW_22_192 VGND VPWR sky130_fd_sc_hd__tapvpwrvgnd_1
XTAP_TAPCELL_ROW_5_116 VGND VPWR sky130_fd_sc_hd__tapvpwrvgnd_1
XTAP_TAPCELL_ROW_28_218 VGND VPWR sky130_fd_sc_hd__tapvpwrvgnd_1
XFILLER_41_237 VPWR VGND VPWR VGND sky130_ef_sc_hd__decap_12
XFILLER_5_149 VPWR VGND VPWR VGND sky130_ef_sc_hd__decap_12
X_604_ clknet_4_0_0_wclk _060_ VGND VGND VPWR VPWR bram.mem\[7\]\[4\] sky130_fd_sc_hd__dfxtp_1
X_535_ clknet_1_1__leaf_rclk sync_gwptr_to_rd.q1\[3\] net2 VGND VGND VPWR VPWR sync_gwptr_to_rd.q2\[3\]
+ sky130_fd_sc_hd__dfrtp_1
XFILLER_43_81 VGND VGND VPWR VPWR sky130_fd_sc_hd__decap_3
X_466_ net6 bram.mem\[5\]\[3\] _246_ VGND VGND VPWR VPWR _083_ sky130_fd_sc_hd__mux2_1
X_397_ bram.waddr\[1\] net23 _203_ bram.waddr\[0\] VGND VGND VPWR VPWR _237_ sky130_fd_sc_hd__nand4b_4
XTAP_TAPCELL_ROW_10_140 VGND VPWR sky130_fd_sc_hd__tapvpwrvgnd_1
XFILLER_4_97 VGND VGND VPWR VPWR sky130_fd_sc_hd__decap_6
XTAP_TAPCELL_ROW_33_243 VGND VPWR sky130_fd_sc_hd__tapvpwrvgnd_1
XFILLER_13_51 VGND VGND VPWR VPWR sky130_fd_sc_hd__decap_4
XFILLER_14_248 VGND VGND VPWR VPWR sky130_fd_sc_hd__decap_4
X_320_ bram.raddr\[2\] _192_ VGND VGND VPWR VPWR _195_ sky130_fd_sc_hd__nor2_1
XFILLER_1_185 VPWR VGND VPWR VGND sky130_ef_sc_hd__decap_12
X_518_ bram.mem\[2\]\[2\] net5 _251_ VGND VGND VPWR VPWR _130_ sky130_fd_sc_hd__mux2_1
X_449_ bram.mem\[8\]\[5\] net8 _243_ VGND VGND VPWR VPWR _069_ sky130_fd_sc_hd__mux2_1
Xclkload11 clknet_4_12_0_wclk VGND VGND VPWR VPWR clkload11/Y sky130_fd_sc_hd__clkinv_4
Xclkload5 clknet_4_5_0_wclk VGND VGND VPWR VPWR clkload5/Y sky130_fd_sc_hd__clkinv_4
XFILLER_6_233 VPWR VGND VPWR VGND sky130_ef_sc_hd__decap_12
XFILLER_10_251 VGND VGND VPWR VPWR sky130_fd_sc_hd__fill_1
X_303_ _177_ _182_ VGND VGND VPWR VPWR net14 sky130_fd_sc_hd__and2_1
XFILLER_37_148 VPWR VGND VPWR VGND sky130_ef_sc_hd__decap_12
XFILLER_28_104 VGND VGND VPWR VPWR sky130_fd_sc_hd__decap_6
XFILLER_29_39 VPWR VGND VPWR VGND sky130_ef_sc_hd__decap_12
XFILLER_3_225 VPWR VGND VPWR VGND sky130_ef_sc_hd__decap_12
XFILLER_3_214 VGND VGND VPWR VPWR sky130_fd_sc_hd__decap_8
XFILLER_25_3 VPWR VGND VPWR VGND sky130_ef_sc_hd__decap_12
Xoutput18 net18 VGND VGND VPWR VPWR rdata[3] sky130_fd_sc_hd__buf_1
XFILLER_24_162 VGND VGND VPWR VPWR sky130_fd_sc_hd__decap_6
X_697_ clknet_4_2_0_wclk _135_ VGND VGND VPWR VPWR bram.mem\[2\]\[7\] sky130_fd_sc_hd__dfxtp_1
XPHY_EDGE_ROW_15_Left_59 VGND VGND VPWR VPWR sky130_fd_sc_hd__decap_3
XPHY_EDGE_ROW_5_Right_5 VGND VGND VPWR VPWR sky130_fd_sc_hd__decap_3
XFILLER_26_29 VGND VGND VPWR VPWR sky130_fd_sc_hd__decap_3
X_620_ clknet_4_1_0_wclk _076_ VGND VGND VPWR VPWR bram.mem\[0\]\[4\] sky130_fd_sc_hd__dfxtp_1
X_551_ clknet_4_7_0_wclk sync_grptr_to_wr.q1\[1\] net12 VGND VGND VPWR VPWR r_ptr_gray_sync\[1\]
+ sky130_fd_sc_hd__dfrtp_1
XFILLER_29_221 VGND VGND VPWR VPWR sky130_fd_sc_hd__decap_3
XTAP_TAPCELL_ROW_39_271 VGND VPWR sky130_fd_sc_hd__tapvpwrvgnd_1
X_482_ net4 bram.mem\[3\]\[1\] _248_ VGND VGND VPWR VPWR _097_ sky130_fd_sc_hd__mux2_1
XFILLER_16_51 VGND VGND VPWR VPWR sky130_fd_sc_hd__fill_1
XTAP_TAPCELL_ROW_22_193 VGND VPWR sky130_fd_sc_hd__tapvpwrvgnd_1
XFILLER_32_50 VGND VGND VPWR VPWR sky130_fd_sc_hd__decap_4
XFILLER_32_83 VGND VGND VPWR VPWR sky130_fd_sc_hd__fill_1
XTAP_TAPCELL_ROW_5_117 VGND VPWR sky130_fd_sc_hd__tapvpwrvgnd_1
XTAP_TAPCELL_ROW_28_219 VGND VPWR sky130_fd_sc_hd__tapvpwrvgnd_1
XFILLER_41_205 VGND VGND VPWR VPWR sky130_fd_sc_hd__fill_2
XFILLER_41_249 VGND VGND VPWR VPWR sky130_fd_sc_hd__decap_8
X_465_ net5 bram.mem\[5\]\[2\] _246_ VGND VGND VPWR VPWR _082_ sky130_fd_sc_hd__mux2_1
X_603_ clknet_4_3_0_wclk _059_ VGND VGND VPWR VPWR bram.mem\[7\]\[3\] sky130_fd_sc_hd__dfxtp_1
XFILLER_17_213 VGND VGND VPWR VPWR sky130_fd_sc_hd__decap_8
X_534_ clknet_1_1__leaf_rclk sync_gwptr_to_rd.q1\[2\] net2 VGND VGND VPWR VPWR sync_gwptr_to_rd.q2\[2\]
+ sky130_fd_sc_hd__dfrtp_1
XTAP_TAPCELL_ROW_10_141 VGND VPWR sky130_fd_sc_hd__tapvpwrvgnd_1
X_396_ bram.mem\[14\]\[7\] net10 _236_ VGND VGND VPWR VPWR _023_ sky130_fd_sc_hd__mux2_1
XTAP_TAPCELL_ROW_33_244 VGND VPWR sky130_fd_sc_hd__tapvpwrvgnd_1
XPHY_EDGE_ROW_18_Left_62 VGND VGND VPWR VPWR sky130_fd_sc_hd__decap_3
XTAP_TAPCELL_ROW_24_200 VGND VPWR sky130_fd_sc_hd__tapvpwrvgnd_1
XFILLER_13_63 VGND VGND VPWR VPWR sky130_fd_sc_hd__fill_1
XTAP_TAPCELL_ROW_0_88 VGND VPWR sky130_fd_sc_hd__tapvpwrvgnd_1
XFILLER_1_197 VPWR VGND VPWR VGND sky130_ef_sc_hd__decap_12
X_517_ bram.mem\[2\]\[1\] net4 _251_ VGND VGND VPWR VPWR _129_ sky130_fd_sc_hd__mux2_1
X_448_ bram.mem\[8\]\[4\] net7 _243_ VGND VGND VPWR VPWR _068_ sky130_fd_sc_hd__mux2_1
X_379_ bram.waddr\[1\] net23 _234_ bram.waddr\[0\] VGND VGND VPWR VPWR _235_ sky130_fd_sc_hd__nand4b_4
Xclkload12 clknet_4_13_0_wclk VGND VGND VPWR VPWR clkload12/Y sky130_fd_sc_hd__bufinv_16
Xclkload6 clknet_4_6_0_wclk VGND VGND VPWR VPWR clkload6/Y sky130_fd_sc_hd__clkinv_4
XFILLER_34_29 VGND VGND VPWR VPWR sky130_fd_sc_hd__decap_4
XPHY_EDGE_ROW_3_Left_47 VGND VGND VPWR VPWR sky130_fd_sc_hd__decap_3
X_302_ _138_ _171_ _178_ _180_ _181_ VGND VGND VPWR VPWR _182_ sky130_fd_sc_hd__o2111a_1
XFILLER_6_245 VGND VGND VPWR VPWR sky130_fd_sc_hd__decap_6
XFILLER_36_182 VGND VGND VPWR VPWR sky130_fd_sc_hd__fill_1
XFILLER_3_237 VPWR VGND VPWR VGND sky130_ef_sc_hd__decap_12
XFILLER_42_185 VGND VGND VPWR VPWR sky130_fd_sc_hd__decap_8
XFILLER_42_141 VPWR VGND VPWR VGND sky130_ef_sc_hd__decap_12
XFILLER_18_3 VGND VGND VPWR VPWR sky130_fd_sc_hd__decap_6
Xoutput19 net19 VGND VGND VPWR VPWR rdata[4] sky130_fd_sc_hd__buf_1
XPHY_EDGE_ROW_6_Left_50 VGND VGND VPWR VPWR sky130_fd_sc_hd__decap_3
XTAP_TAPCELL_ROW_17_169 VGND VPWR sky130_fd_sc_hd__tapvpwrvgnd_1
X_696_ clknet_4_8_0_wclk _134_ VGND VGND VPWR VPWR bram.mem\[2\]\[6\] sky130_fd_sc_hd__dfxtp_1
XFILLER_30_177 VPWR VGND VPWR VGND sky130_ef_sc_hd__decap_12
XFILLER_42_29 VPWR VGND VPWR VGND sky130_ef_sc_hd__decap_12
XFILLER_21_133 VGND VGND VPWR VPWR sky130_fd_sc_hd__decap_3
X_481_ net3 bram.mem\[3\]\[0\] _248_ VGND VGND VPWR VPWR _096_ sky130_fd_sc_hd__mux2_1
X_550_ clknet_4_7_0_wclk sync_grptr_to_wr.q1\[0\] net12 VGND VGND VPWR VPWR r_ptr_gray_sync\[0\]
+ sky130_fd_sc_hd__dfrtp_1
XPHY_EDGE_ROW_11_Right_11 VGND VGND VPWR VPWR sky130_fd_sc_hd__decap_3
XFILLER_16_85 VPWR VGND VPWR VGND sky130_ef_sc_hd__decap_12
XTAP_TAPCELL_ROW_22_194 VGND VPWR sky130_fd_sc_hd__tapvpwrvgnd_1
XPHY_EDGE_ROW_32_Left_76 VGND VGND VPWR VPWR sky130_fd_sc_hd__decap_3
XPHY_EDGE_ROW_20_Right_20 VGND VGND VPWR VPWR sky130_fd_sc_hd__decap_3
X_679_ clknet_4_4_0_wclk _117_ VGND VGND VPWR VPWR bram.mem\[1\]\[5\] sky130_fd_sc_hd__dfxtp_1
XFILLER_35_225 VPWR VGND VPWR VGND sky130_ef_sc_hd__decap_12
XTAP_TAPCELL_ROW_5_118 VGND VPWR sky130_fd_sc_hd__tapvpwrvgnd_1
X_602_ clknet_4_0_0_wclk _058_ VGND VGND VPWR VPWR bram.mem\[7\]\[2\] sky130_fd_sc_hd__dfxtp_1
X_464_ net4 bram.mem\[5\]\[1\] _246_ VGND VGND VPWR VPWR _081_ sky130_fd_sc_hd__mux2_1
XFILLER_17_225 VGND VGND VPWR VPWR sky130_fd_sc_hd__fill_2
XFILLER_17_247 VGND VGND VPWR VPWR sky130_fd_sc_hd__decap_8
X_533_ clknet_1_1__leaf_rclk sync_gwptr_to_rd.q1\[1\] net2 VGND VGND VPWR VPWR sync_gwptr_to_rd.q2\[1\]
+ sky130_fd_sc_hd__dfrtp_1
X_395_ bram.mem\[14\]\[6\] net9 _236_ VGND VGND VPWR VPWR _022_ sky130_fd_sc_hd__mux2_1
XTAP_TAPCELL_ROW_24_201 VGND VPWR sky130_fd_sc_hd__tapvpwrvgnd_1
XFILLER_22_250 VGND VGND VPWR VPWR sky130_fd_sc_hd__fill_2
XTAP_TAPCELL_ROW_0_89 VGND VPWR sky130_fd_sc_hd__tapvpwrvgnd_1
XFILLER_38_50 VGND VGND VPWR VPWR sky130_fd_sc_hd__decap_4
X_516_ bram.mem\[2\]\[0\] net3 _251_ VGND VGND VPWR VPWR _128_ sky130_fd_sc_hd__mux2_1
XFILLER_20_209 VPWR VGND VPWR VGND sky130_ef_sc_hd__decap_12
X_378_ _138_ bram.waddr\[2\] VGND VGND VPWR VPWR _234_ sky130_fd_sc_hd__nor2_2
X_447_ bram.mem\[8\]\[3\] net6 _243_ VGND VGND VPWR VPWR _067_ sky130_fd_sc_hd__mux2_1
Xclkload13 clknet_4_14_0_wclk VGND VGND VPWR VPWR clkload13/Y sky130_fd_sc_hd__clkinvlp_4
Xclkload7 clknet_4_7_0_wclk VGND VGND VPWR VPWR clkload7/Y sky130_fd_sc_hd__clkinv_2
X_301_ bram.waddr\[2\] _172_ VGND VGND VPWR VPWR _181_ sky130_fd_sc_hd__or2_1
XFILLER_24_85 VGND VGND VPWR VPWR sky130_fd_sc_hd__decap_3
XFILLER_10_253 VGND VGND VPWR VPWR sky130_fd_sc_hd__decap_4
XFILLER_34_9 VPWR VGND VPWR VGND sky130_ef_sc_hd__decap_12
XFILLER_28_139 VGND VGND VPWR VPWR sky130_fd_sc_hd__fill_1
XFILLER_43_109 VGND VGND VPWR VPWR sky130_fd_sc_hd__decap_3
XFILLER_3_249 VGND VGND VPWR VPWR sky130_fd_sc_hd__decap_8
XFILLER_27_150 VGND VGND VPWR VPWR sky130_fd_sc_hd__fill_1
XFILLER_34_109 VGND VGND VPWR VPWR sky130_fd_sc_hd__decap_6
XFILLER_42_197 VPWR VGND VPWR VGND sky130_ef_sc_hd__decap_12
XFILLER_25_109 VGND VGND VPWR VPWR sky130_fd_sc_hd__decap_3
X_695_ clknet_4_1_0_wclk _133_ VGND VGND VPWR VPWR bram.mem\[2\]\[5\] sky130_fd_sc_hd__dfxtp_1
XFILLER_30_189 VGND VGND VPWR VPWR sky130_fd_sc_hd__decap_6
XFILLER_30_3 VPWR VGND VPWR VGND sky130_ef_sc_hd__decap_12
XFILLER_21_101 VGND VGND VPWR VPWR sky130_fd_sc_hd__decap_8
XFILLER_21_145 VGND VGND VPWR VPWR sky130_fd_sc_hd__decap_4
X_480_ bram.waddr\[0\] bram.waddr\[1\] net23 _244_ VGND VGND VPWR VPWR _248_ sky130_fd_sc_hd__nand4_4
XFILLER_29_256 VGND VGND VPWR VPWR sky130_fd_sc_hd__fill_1
XFILLER_8_138 VGND VGND VPWR VPWR sky130_fd_sc_hd__fill_2
XFILLER_12_123 VGND VGND VPWR VPWR sky130_fd_sc_hd__fill_1
XFILLER_16_97 VGND VGND VPWR VPWR sky130_fd_sc_hd__fill_2
XTAP_TAPCELL_ROW_22_195 VGND VPWR sky130_fd_sc_hd__tapvpwrvgnd_1
XFILLER_32_63 VPWR VGND VPWR VGND sky130_ef_sc_hd__decap_12
XFILLER_32_85 VPWR VGND VPWR VGND sky130_ef_sc_hd__decap_12
X_678_ clknet_4_1_0_wclk _116_ VGND VGND VPWR VPWR bram.mem\[1\]\[4\] sky130_fd_sc_hd__dfxtp_1
XTAP_TAPCELL_ROW_13_151 VGND VPWR sky130_fd_sc_hd__tapvpwrvgnd_1
XTAP_TAPCELL_ROW_36_254 VGND VPWR sky130_fd_sc_hd__tapvpwrvgnd_1
XFILLER_41_218 VGND VGND VPWR VPWR sky130_fd_sc_hd__decap_6
X_601_ clknet_4_6_0_wclk _057_ VGND VGND VPWR VPWR bram.mem\[7\]\[1\] sky130_fd_sc_hd__dfxtp_1
X_463_ net3 bram.mem\[5\]\[0\] _246_ VGND VGND VPWR VPWR _080_ sky130_fd_sc_hd__mux2_1
X_394_ bram.mem\[14\]\[5\] net8 _236_ VGND VGND VPWR VPWR _021_ sky130_fd_sc_hd__mux2_1
X_532_ clknet_1_1__leaf_rclk sync_gwptr_to_rd.q1\[0\] net2 VGND VGND VPWR VPWR sync_gwptr_to_rd.q2\[0\]
+ sky130_fd_sc_hd__dfrtp_1
XFILLER_4_141 VPWR VGND VPWR VGND sky130_ef_sc_hd__decap_12
XTAP_TAPCELL_ROW_1_100 VGND VPWR sky130_fd_sc_hd__tapvpwrvgnd_1
XFILLER_14_207 VGND VGND VPWR VPWR sky130_fd_sc_hd__fill_1
XTAP_TAPCELL_ROW_24_202 VGND VPWR sky130_fd_sc_hd__tapvpwrvgnd_1
XFILLER_8_3 VPWR VGND VPWR VGND sky130_ef_sc_hd__decap_12
XFILLER_1_166 VGND VGND VPWR VPWR sky130_fd_sc_hd__fill_2
X_515_ bram.waddr\[0\] bram.waddr\[1\] net23 _244_ VGND VGND VPWR VPWR _251_ sky130_fd_sc_hd__and4b_4
XFILLER_9_211 VPWR VGND VPWR VGND sky130_ef_sc_hd__decap_12
X_446_ bram.mem\[8\]\[2\] net5 _243_ VGND VGND VPWR VPWR _066_ sky130_fd_sc_hd__mux2_1
XTAP_TAPCELL_ROW_30_227 VGND VPWR sky130_fd_sc_hd__tapvpwrvgnd_1
X_377_ _228_ _230_ _233_ _137_ VGND VGND VPWR VPWR _003_ sky130_fd_sc_hd__a22o_1
Xclkload14 clknet_4_15_0_wclk VGND VGND VPWR VPWR clkload14/Y sky130_fd_sc_hd__clkinv_4
Xclkload8 clknet_4_9_0_wclk VGND VGND VPWR VPWR clkload8/Y sky130_fd_sc_hd__clkinvlp_4
XFILLER_10_221 VPWR VGND VPWR VGND sky130_ef_sc_hd__decap_12
X_300_ _138_ _171_ _179_ VGND VGND VPWR VPWR _180_ sky130_fd_sc_hd__a21oi_1
Xclkbuf_4_5_0_wclk clknet_0_wclk VGND VGND VPWR VPWR clknet_4_5_0_wclk sky130_fd_sc_hd__clkbuf_8
XFILLER_40_41 VGND VGND VPWR VPWR sky130_fd_sc_hd__fill_2
XFILLER_40_85 VGND VGND VPWR VPWR sky130_fd_sc_hd__decap_3
XFILLER_27_9 VGND VGND VPWR VPWR sky130_fd_sc_hd__fill_1
XFILLER_1_57 VGND VGND VPWR VPWR sky130_fd_sc_hd__decap_3
X_429_ bram.mem\[10\]\[4\] net7 _240_ VGND VGND VPWR VPWR _052_ sky130_fd_sc_hd__mux2_1
Xinput1 ren VGND VGND VPWR VPWR net1 sky130_fd_sc_hd__clkbuf_1
XFILLER_36_195 VGND VGND VPWR VPWR sky130_fd_sc_hd__fill_1
XFILLER_19_53 VGND VGND VPWR VPWR sky130_fd_sc_hd__decap_3
Xclkbuf_4_13_0_wclk clknet_0_wclk VGND VGND VPWR VPWR clknet_4_13_0_wclk sky130_fd_sc_hd__clkbuf_8
XFILLER_18_195 VGND VGND VPWR VPWR sky130_fd_sc_hd__fill_1
XFILLER_0_209 VPWR VGND VPWR VGND sky130_ef_sc_hd__decap_12
X_694_ clknet_4_0_0_wclk _132_ VGND VGND VPWR VPWR bram.mem\[2\]\[4\] sky130_fd_sc_hd__dfxtp_1
XFILLER_15_154 VGND VGND VPWR VPWR sky130_fd_sc_hd__decap_6
XFILLER_23_3 VGND VGND VPWR VPWR sky130_fd_sc_hd__decap_4
XFILLER_38_202 VGND VGND VPWR VPWR sky130_fd_sc_hd__decap_3
XFILLER_21_113 VPWR VGND VPWR VGND sky130_ef_sc_hd__decap_12
XTAP_TAPCELL_ROW_8_128 VGND VPWR sky130_fd_sc_hd__tapvpwrvgnd_1
Xclkbuf_0_rclk rclk VGND VGND VPWR VPWR clknet_0_rclk sky130_fd_sc_hd__clkbuf_16
XFILLER_8_106 VGND VGND VPWR VPWR sky130_fd_sc_hd__fill_2
XFILLER_32_75 VGND VGND VPWR VPWR sky130_fd_sc_hd__decap_8
XFILLER_32_97 VGND VGND VPWR VPWR sky130_fd_sc_hd__decap_8
X_677_ clknet_4_6_0_wclk _115_ VGND VGND VPWR VPWR bram.mem\[1\]\[3\] sky130_fd_sc_hd__dfxtp_1
XTAP_TAPCELL_ROW_13_152 VGND VPWR sky130_fd_sc_hd__tapvpwrvgnd_1
XPHY_EDGE_ROW_9_Right_9 VGND VGND VPWR VPWR sky130_fd_sc_hd__decap_3
XTAP_TAPCELL_ROW_36_255 VGND VPWR sky130_fd_sc_hd__tapvpwrvgnd_1
X_600_ clknet_4_4_0_wclk _056_ VGND VGND VPWR VPWR bram.mem\[7\]\[0\] sky130_fd_sc_hd__dfxtp_1
X_531_ clknet_4_10_0_wclk _015_ VGND VGND VPWR VPWR bram.mem\[9\]\[7\] sky130_fd_sc_hd__dfxtp_1
XFILLER_43_85 VPWR VGND VPWR VGND sky130_ef_sc_hd__decap_12
XFILLER_43_41 VPWR VGND VPWR VGND sky130_ef_sc_hd__decap_12
X_462_ bram.waddr\[1\] net23 _241_ bram.waddr\[0\] VGND VGND VPWR VPWR _246_ sky130_fd_sc_hd__nand4b_4
X_393_ bram.mem\[14\]\[4\] net7 _236_ VGND VGND VPWR VPWR _020_ sky130_fd_sc_hd__mux2_1
XFILLER_4_153 VPWR VGND VPWR VGND sky130_ef_sc_hd__decap_12
XFILLER_4_197 VPWR VGND VPWR VGND sky130_ef_sc_hd__decap_12
XTAP_TAPCELL_ROW_41_280 VGND VPWR sky130_fd_sc_hd__tapvpwrvgnd_1
XFILLER_13_11 VGND VGND VPWR VPWR sky130_fd_sc_hd__fill_1
XTAP_TAPCELL_ROW_24_203 VGND VPWR sky130_fd_sc_hd__tapvpwrvgnd_1
XFILLER_13_55 VGND VGND VPWR VPWR sky130_fd_sc_hd__fill_1
XFILLER_1_156 VGND VGND VPWR VPWR sky130_fd_sc_hd__fill_1
XFILLER_38_63 VPWR VGND VPWR VGND sky130_ef_sc_hd__decap_12
X_514_ net10 bram.mem\[15\]\[7\] _204_ VGND VGND VPWR VPWR _127_ sky130_fd_sc_hd__mux2_1
XFILLER_38_85 VGND VGND VPWR VPWR sky130_fd_sc_hd__decap_4
XFILLER_9_223 VGND VGND VPWR VPWR sky130_fd_sc_hd__fill_1
X_376_ _231_ _232_ bram.raddr\[2\] VGND VGND VPWR VPWR _233_ sky130_fd_sc_hd__mux2_1
XTAP_TAPCELL_ROW_30_228 VGND VPWR sky130_fd_sc_hd__tapvpwrvgnd_1
Xclkload15 clknet_1_0__leaf_rclk VGND VGND VPWR VPWR clkload15/Y sky130_fd_sc_hd__inv_4
X_445_ bram.mem\[8\]\[1\] net4 _243_ VGND VGND VPWR VPWR _065_ sky130_fd_sc_hd__mux2_1
Xclkload9 clknet_4_10_0_wclk VGND VGND VPWR VPWR clkload9/X sky130_fd_sc_hd__clkbuf_8
XFILLER_39_182 VGND VGND VPWR VPWR sky130_fd_sc_hd__fill_1
XFILLER_10_233 VPWR VGND VPWR VGND sky130_ef_sc_hd__decap_12
XFILLER_24_76 VGND VGND VPWR VPWR sky130_fd_sc_hd__decap_8
X_428_ bram.mem\[10\]\[3\] net6 _240_ VGND VGND VPWR VPWR _051_ sky130_fd_sc_hd__mux2_1
X_359_ bram.mem\[4\]\[1\] bram.mem\[5\]\[1\] bram.mem\[6\]\[1\] bram.mem\[7\]\[1\]
+ bram.raddr\[0\] bram.raddr\[1\] VGND VGND VPWR VPWR _218_ sky130_fd_sc_hd__mux4_1
XFILLER_28_119 VPWR VGND VPWR VGND sky130_ef_sc_hd__decap_12
Xinput2 rrst_n VGND VGND VPWR VPWR net2 sky130_fd_sc_hd__clkbuf_8
XFILLER_19_65 VGND VGND VPWR VPWR sky130_fd_sc_hd__fill_1
XFILLER_2_251 VGND VGND VPWR VPWR sky130_fd_sc_hd__fill_1
XFILLER_18_141 VGND VGND VPWR VPWR sky130_fd_sc_hd__decap_8
XFILLER_33_166 VGND VGND VPWR VPWR sky130_fd_sc_hd__fill_2
XTAP_TAPCELL_ROW_19_180 VGND VPWR sky130_fd_sc_hd__tapvpwrvgnd_1
XFILLER_21_55 VGND VGND VPWR VPWR sky130_fd_sc_hd__fill_1
X_693_ clknet_4_3_0_wclk _131_ VGND VGND VPWR VPWR bram.mem\[2\]\[3\] sky130_fd_sc_hd__dfxtp_1
XFILLER_15_111 VGND VGND VPWR VPWR sky130_fd_sc_hd__fill_1
XFILLER_15_122 VGND VGND VPWR VPWR sky130_fd_sc_hd__decap_6
XFILLER_7_57 VGND VGND VPWR VPWR sky130_fd_sc_hd__decap_6
XFILLER_16_3 VGND VGND VPWR VPWR sky130_fd_sc_hd__decap_4
XFILLER_21_125 VGND VGND VPWR VPWR sky130_fd_sc_hd__decap_8
XFILLER_21_169 VGND VGND VPWR VPWR sky130_fd_sc_hd__fill_1
XTAP_TAPCELL_ROW_8_129 VGND VPWR sky130_fd_sc_hd__tapvpwrvgnd_1
XFILLER_29_225 VGND VGND VPWR VPWR sky130_fd_sc_hd__decap_4
XFILLER_20_180 VGND VGND VPWR VPWR sky130_fd_sc_hd__fill_1
X_676_ clknet_4_0_0_wclk _114_ VGND VGND VPWR VPWR bram.mem\[1\]\[2\] sky130_fd_sc_hd__dfxtp_1
XFILLER_35_206 VPWR VGND VPWR VGND sky130_ef_sc_hd__decap_12
XTAP_TAPCELL_ROW_13_153 VGND VPWR sky130_fd_sc_hd__tapvpwrvgnd_1
XTAP_TAPCELL_ROW_36_256 VGND VPWR sky130_fd_sc_hd__tapvpwrvgnd_1
XTAP_TAPCELL_ROW_4_110 VGND VPWR sky130_fd_sc_hd__tapvpwrvgnd_1
X_461_ bram.mem\[0\]\[7\] net10 _245_ VGND VGND VPWR VPWR _079_ sky130_fd_sc_hd__mux2_1
X_530_ clknet_4_11_0_wclk _014_ VGND VGND VPWR VPWR bram.mem\[9\]\[6\] sky130_fd_sc_hd__dfxtp_1
XFILLER_43_97 VPWR VGND VPWR VGND sky130_ef_sc_hd__decap_12
XFILLER_43_53 VGND VGND VPWR VPWR sky130_fd_sc_hd__decap_3
X_392_ bram.mem\[14\]\[3\] net6 _236_ VGND VGND VPWR VPWR _019_ sky130_fd_sc_hd__mux2_1
XFILLER_40_253 VGND VGND VPWR VPWR sky130_fd_sc_hd__decap_4
XFILLER_4_165 VGND VGND VPWR VPWR sky130_fd_sc_hd__decap_4
XFILLER_4_58 VGND VGND VPWR VPWR sky130_fd_sc_hd__decap_4
XFILLER_31_231 VGND VGND VPWR VPWR sky130_fd_sc_hd__fill_1
X_659_ clknet_1_0__leaf_rclk u_rptr_handler.b_rptr_next\[2\] net2 VGND VGND VPWR VPWR
+ bram.raddr\[2\] sky130_fd_sc_hd__dfrtp_4
XFILLER_22_242 VGND VGND VPWR VPWR sky130_fd_sc_hd__decap_8
XFILLER_22_253 VGND VGND VPWR VPWR sky130_fd_sc_hd__decap_4
XTAP_TAPCELL_ROW_24_204 VGND VPWR sky130_fd_sc_hd__tapvpwrvgnd_1
XFILLER_38_75 VGND VGND VPWR VPWR sky130_fd_sc_hd__decap_3
X_444_ bram.mem\[8\]\[0\] net3 _243_ VGND VGND VPWR VPWR _064_ sky130_fd_sc_hd__mux2_1
X_513_ net9 bram.mem\[15\]\[6\] _204_ VGND VGND VPWR VPWR _126_ sky130_fd_sc_hd__mux2_1
X_375_ bram.mem\[4\]\[3\] bram.mem\[5\]\[3\] bram.mem\[6\]\[3\] bram.mem\[7\]\[3\]
+ bram.raddr\[0\] bram.raddr\[1\] VGND VGND VPWR VPWR _232_ sky130_fd_sc_hd__mux4_1
XTAP_TAPCELL_ROW_30_229 VGND VPWR sky130_fd_sc_hd__tapvpwrvgnd_1
XFILLER_10_245 VGND VGND VPWR VPWR sky130_fd_sc_hd__decap_6
XFILLER_40_21 VGND VGND VPWR VPWR sky130_fd_sc_hd__decap_6
XFILLER_1_15 VPWR VGND VPWR VGND sky130_ef_sc_hd__decap_12
XFILLER_37_109 VGND VGND VPWR VPWR sky130_fd_sc_hd__decap_3
XPHY_EDGE_ROW_39_Left_83 VGND VGND VPWR VPWR sky130_fd_sc_hd__decap_3
X_358_ bram.mem\[0\]\[1\] bram.mem\[1\]\[1\] bram.mem\[2\]\[1\] bram.mem\[3\]\[1\]
+ bram.raddr\[0\] bram.raddr\[1\] VGND VGND VPWR VPWR _217_ sky130_fd_sc_hd__mux4_1
XPHY_EDGE_ROW_23_Left_67 VGND VGND VPWR VPWR sky130_fd_sc_hd__decap_3
X_427_ bram.mem\[10\]\[2\] net5 _240_ VGND VGND VPWR VPWR _050_ sky130_fd_sc_hd__mux2_1
X_289_ _168_ _169_ bram.raddr\[2\] VGND VGND VPWR VPWR _170_ sky130_fd_sc_hd__mux2_1
XPHY_EDGE_ROW_18_Right_18 VGND VGND VPWR VPWR sky130_fd_sc_hd__decap_3
Xinput3 wdata[0] VGND VGND VPWR VPWR net3 sky130_fd_sc_hd__clkbuf_4
XPHY_EDGE_ROW_27_Right_27 VGND VGND VPWR VPWR sky130_fd_sc_hd__decap_3
XFILLER_36_153 VGND VGND VPWR VPWR sky130_fd_sc_hd__fill_1
XFILLER_10_46 VPWR VGND VPWR VGND sky130_ef_sc_hd__decap_12
XPHY_EDGE_ROW_36_Right_36 VGND VGND VPWR VPWR sky130_fd_sc_hd__decap_3
XFILLER_19_99 VGND VGND VPWR VPWR sky130_fd_sc_hd__fill_1
XFILLER_19_109 VGND VGND VPWR VPWR sky130_fd_sc_hd__decap_3
XFILLER_42_123 VGND VGND VPWR VPWR sky130_fd_sc_hd__fill_1
XFILLER_27_175 VGND VGND VPWR VPWR sky130_fd_sc_hd__decap_6
XFILLER_2_91 VGND VGND VPWR VPWR sky130_fd_sc_hd__fill_1
XTAP_TAPCELL_ROW_19_181 VGND VPWR sky130_fd_sc_hd__tapvpwrvgnd_1
XFILLER_21_89 VGND VGND VPWR VPWR sky130_fd_sc_hd__decap_3
X_692_ clknet_4_0_0_wclk _130_ VGND VGND VPWR VPWR bram.mem\[2\]\[2\] sky130_fd_sc_hd__dfxtp_1
XFILLER_15_189 VGND VGND VPWR VPWR sky130_fd_sc_hd__fill_1
XPHY_EDGE_ROW_26_Left_70 VGND VGND VPWR VPWR sky130_fd_sc_hd__decap_3
XPHY_EDGE_ROW_10_Left_54 VGND VGND VPWR VPWR sky130_fd_sc_hd__decap_3
XFILLER_16_23 VGND VGND VPWR VPWR sky130_fd_sc_hd__decap_4
XPHY_EDGE_ROW_0_Right_0 VGND VGND VPWR VPWR sky130_fd_sc_hd__decap_3
XFILLER_12_159 VGND VGND VPWR VPWR sky130_fd_sc_hd__fill_1
XFILLER_16_45 VGND VGND VPWR VPWR sky130_fd_sc_hd__decap_6
X_675_ clknet_4_6_0_wclk _113_ VGND VGND VPWR VPWR bram.mem\[1\]\[1\] sky130_fd_sc_hd__dfxtp_1
XFILLER_35_218 VGND VGND VPWR VPWR sky130_fd_sc_hd__decap_6
XTAP_TAPCELL_ROW_13_154 VGND VPWR sky130_fd_sc_hd__tapvpwrvgnd_1
XFILLER_7_185 VPWR VGND VPWR VGND sky130_ef_sc_hd__decap_12
XTAP_TAPCELL_ROW_36_257 VGND VPWR sky130_fd_sc_hd__tapvpwrvgnd_1
XTAP_TAPCELL_ROW_4_111 VGND VPWR sky130_fd_sc_hd__tapvpwrvgnd_1
X_460_ bram.mem\[0\]\[6\] net9 _245_ VGND VGND VPWR VPWR _078_ sky130_fd_sc_hd__mux2_1
X_391_ bram.mem\[14\]\[2\] net5 _236_ VGND VGND VPWR VPWR _018_ sky130_fd_sc_hd__mux2_1
XFILLER_27_66 VGND VGND VPWR VPWR sky130_fd_sc_hd__decap_4
XFILLER_4_15 VPWR VGND VPWR VGND sky130_ef_sc_hd__decap_12
XFILLER_16_251 VGND VGND VPWR VPWR sky130_fd_sc_hd__fill_1
X_589_ clknet_4_8_0_wclk _045_ VGND VGND VPWR VPWR bram.mem\[11\]\[5\] sky130_fd_sc_hd__dfxtp_1
XFILLER_31_243 VGND VGND VPWR VPWR sky130_fd_sc_hd__decap_3
X_658_ clknet_1_0__leaf_rclk u_rptr_handler.b_rptr_next\[1\] net2 VGND VGND VPWR VPWR
+ bram.raddr\[1\] sky130_fd_sc_hd__dfrtp_4
XFILLER_13_57 VGND VGND VPWR VPWR sky130_fd_sc_hd__decap_6
XFILLER_9_225 VPWR VGND VPWR VGND sky130_ef_sc_hd__decap_12
XFILLER_13_210 VPWR VGND VPWR VGND sky130_ef_sc_hd__decap_12
X_374_ bram.mem\[0\]\[3\] bram.mem\[1\]\[3\] bram.mem\[2\]\[3\] bram.mem\[3\]\[3\]
+ bram.raddr\[0\] bram.raddr\[1\] VGND VGND VPWR VPWR _231_ sky130_fd_sc_hd__mux4_1
X_512_ net8 bram.mem\[15\]\[5\] _204_ VGND VGND VPWR VPWR _125_ sky130_fd_sc_hd__mux2_1
X_443_ bram.waddr\[0\] bram.waddr\[1\] net23 _234_ VGND VGND VPWR VPWR _243_ sky130_fd_sc_hd__and4bb_4
XFILLER_5_80 VGND VGND VPWR VPWR sky130_fd_sc_hd__decap_8
XFILLER_24_45 VGND VGND VPWR VPWR sky130_fd_sc_hd__fill_2
XFILLER_24_56 VGND VGND VPWR VPWR sky130_fd_sc_hd__decap_4
XFILLER_6_3 VPWR VGND VPWR VGND sky130_ef_sc_hd__decap_12
XFILLER_1_27 VPWR VGND VPWR VGND sky130_ef_sc_hd__decap_12
X_426_ bram.mem\[10\]\[1\] net4 _240_ VGND VGND VPWR VPWR _049_ sky130_fd_sc_hd__mux2_1
X_357_ bram.raddr\[2\] _215_ bram.raddr\[3\] VGND VGND VPWR VPWR _216_ sky130_fd_sc_hd__o21a_1
X_288_ bram.mem\[4\]\[7\] bram.mem\[5\]\[7\] bram.mem\[6\]\[7\] bram.mem\[7\]\[7\]
+ bram.raddr\[0\] bram.raddr\[1\] VGND VGND VPWR VPWR _169_ sky130_fd_sc_hd__mux4_1
Xinput4 wdata[1] VGND VGND VPWR VPWR net4 sky130_fd_sc_hd__clkbuf_4
XFILLER_39_3 VGND VGND VPWR VPWR sky130_fd_sc_hd__decap_8
XFILLER_36_165 VGND VGND VPWR VPWR sky130_fd_sc_hd__decap_4
XFILLER_36_176 VGND VGND VPWR VPWR sky130_fd_sc_hd__decap_6
XFILLER_10_58 VPWR VGND VPWR VGND sky130_ef_sc_hd__decap_12
XPHY_EDGE_ROW_40_Left_84 VGND VGND VPWR VPWR sky130_fd_sc_hd__decap_3
XFILLER_19_45 VGND VGND VPWR VPWR sky130_fd_sc_hd__decap_8
XFILLER_2_253 VGND VGND VPWR VPWR sky130_fd_sc_hd__decap_4
XFILLER_33_113 VPWR VGND VPWR VGND sky130_ef_sc_hd__decap_12
X_409_ bram.mem\[12\]\[2\] net5 _238_ VGND VGND VPWR VPWR _034_ sky130_fd_sc_hd__mux2_1
XFILLER_24_135 VGND VGND VPWR VPWR sky130_fd_sc_hd__decap_4
XFILLER_24_168 VGND VGND VPWR VPWR sky130_fd_sc_hd__fill_1
XFILLER_21_57 VPWR VGND VPWR VGND sky130_ef_sc_hd__decap_12
X_691_ clknet_4_5_0_wclk _129_ VGND VGND VPWR VPWR bram.mem\[2\]\[1\] sky130_fd_sc_hd__dfxtp_1
XFILLER_7_15 VGND VGND VPWR VPWR sky130_fd_sc_hd__decap_4
XFILLER_30_138 VGND VGND VPWR VPWR sky130_fd_sc_hd__fill_2
XFILLER_38_249 VGND VGND VPWR VPWR sky130_fd_sc_hd__decap_3
XFILLER_16_68 VGND VGND VPWR VPWR sky130_fd_sc_hd__decap_6
XFILLER_12_105 VGND VGND VPWR VPWR sky130_fd_sc_hd__fill_2
XFILLER_20_193 VGND VGND VPWR VPWR sky130_fd_sc_hd__decap_3
X_674_ clknet_4_5_0_wclk _112_ VGND VGND VPWR VPWR bram.mem\[1\]\[0\] sky130_fd_sc_hd__dfxtp_1
XFILLER_7_197 VPWR VGND VPWR VGND sky130_ef_sc_hd__decap_12
XFILLER_21_3 VPWR VGND VPWR VGND sky130_ef_sc_hd__decap_12
XFILLER_26_219 VPWR VGND VPWR VGND sky130_ef_sc_hd__decap_12
XTAP_TAPCELL_ROW_36_258 VGND VPWR sky130_fd_sc_hd__tapvpwrvgnd_1
XTAP_TAPCELL_ROW_4_112 VGND VPWR sky130_fd_sc_hd__tapvpwrvgnd_1
XTAP_TAPCELL_ROW_27_214 VGND VPWR sky130_fd_sc_hd__tapvpwrvgnd_1
X_390_ bram.mem\[14\]\[1\] net4 _236_ VGND VGND VPWR VPWR _017_ sky130_fd_sc_hd__mux2_1
XFILLER_4_178 VPWR VGND VPWR VGND sky130_ef_sc_hd__decap_12
XFILLER_4_27 VGND VGND VPWR VPWR sky130_fd_sc_hd__fill_1
X_657_ clknet_1_1__leaf_rclk u_rptr_handler.b_rptr_next\[0\] net2 VGND VGND VPWR VPWR
+ bram.raddr\[0\] sky130_fd_sc_hd__dfrtp_4
X_588_ clknet_4_10_0_wclk _044_ VGND VGND VPWR VPWR bram.mem\[11\]\[4\] sky130_fd_sc_hd__dfxtp_1
XFILLER_1_148 VGND VGND VPWR VPWR sky130_fd_sc_hd__decap_8
X_511_ net7 bram.mem\[15\]\[4\] _204_ VGND VGND VPWR VPWR _124_ sky130_fd_sc_hd__mux2_1
XFILLER_38_22 VGND VGND VPWR VPWR sky130_fd_sc_hd__decap_6
XFILLER_38_99 VPWR VGND VPWR VGND sky130_ef_sc_hd__decap_12
XFILLER_9_237 VPWR VGND VPWR VGND sky130_ef_sc_hd__decap_12
X_442_ net10 bram.mem\[7\]\[7\] _242_ VGND VGND VPWR VPWR _063_ sky130_fd_sc_hd__mux2_1
XFILLER_13_222 VGND VGND VPWR VPWR sky130_fd_sc_hd__fill_2
X_373_ _136_ _229_ bram.raddr\[3\] VGND VGND VPWR VPWR _230_ sky130_fd_sc_hd__o21a_1
Xclkbuf_4_0_0_wclk clknet_0_wclk VGND VGND VPWR VPWR clknet_4_0_0_wclk sky130_fd_sc_hd__clkbuf_8
XFILLER_24_24 VGND VGND VPWR VPWR sky130_fd_sc_hd__decap_4
XFILLER_24_35 VGND VGND VPWR VPWR sky130_fd_sc_hd__fill_1
XFILLER_1_39 VGND VGND VPWR VPWR sky130_fd_sc_hd__fill_1
X_287_ bram.mem\[0\]\[7\] bram.mem\[1\]\[7\] bram.mem\[2\]\[7\] bram.mem\[3\]\[7\]
+ bram.raddr\[0\] bram.raddr\[1\] VGND VGND VPWR VPWR _168_ sky130_fd_sc_hd__mux4_1
X_425_ bram.mem\[10\]\[0\] net3 _240_ VGND VGND VPWR VPWR _048_ sky130_fd_sc_hd__mux2_1
X_356_ bram.mem\[8\]\[1\] bram.mem\[9\]\[1\] bram.mem\[10\]\[1\] bram.mem\[11\]\[1\]
+ bram.raddr\[0\] bram.raddr\[1\] VGND VGND VPWR VPWR _215_ sky130_fd_sc_hd__mux4_1
Xinput5 wdata[2] VGND VGND VPWR VPWR net5 sky130_fd_sc_hd__clkbuf_4
XFILLER_10_15 VPWR VGND VPWR VGND sky130_ef_sc_hd__decap_12
XFILLER_19_35 VGND VGND VPWR VPWR sky130_fd_sc_hd__fill_1
XFILLER_19_57 VGND VGND VPWR VPWR sky130_fd_sc_hd__decap_8
XFILLER_2_221 VPWR VGND VPWR VGND sky130_ef_sc_hd__decap_12
XFILLER_18_9 VGND VGND VPWR VPWR sky130_fd_sc_hd__fill_1
XFILLER_33_125 VGND VGND VPWR VPWR sky130_fd_sc_hd__fill_2
XFILLER_33_169 VGND VGND VPWR VPWR sky130_fd_sc_hd__decap_3
X_408_ bram.mem\[12\]\[1\] net4 _238_ VGND VGND VPWR VPWR _033_ sky130_fd_sc_hd__mux2_1
X_339_ bram.waddr\[3\] bram.waddr\[2\] VGND VGND VPWR VPWR _203_ sky130_fd_sc_hd__and2_2
XFILLER_32_191 VGND VGND VPWR VPWR sky130_fd_sc_hd__decap_4
XFILLER_21_69 VPWR VGND VPWR VGND sky130_ef_sc_hd__decap_12
X_690_ clknet_4_5_0_wclk _128_ VGND VGND VPWR VPWR bram.mem\[2\]\[0\] sky130_fd_sc_hd__dfxtp_1
Xmax_cap23 _198_ VGND VGND VPWR VPWR net23 sky130_fd_sc_hd__buf_8
XTAP_TAPCELL_ROW_16_164 VGND VPWR sky130_fd_sc_hd__tapvpwrvgnd_1
X_673_ clknet_4_2_0_wclk _111_ VGND VGND VPWR VPWR bram.mem\[4\]\[7\] sky130_fd_sc_hd__dfxtp_1
XFILLER_43_253 VGND VGND VPWR VPWR sky130_fd_sc_hd__decap_4
XFILLER_14_3 VPWR VGND VPWR VGND sky130_ef_sc_hd__decap_12
XFILLER_34_253 VGND VGND VPWR VPWR sky130_fd_sc_hd__decap_4
XTAP_TAPCELL_ROW_4_113 VGND VPWR sky130_fd_sc_hd__tapvpwrvgnd_1
XTAP_TAPCELL_ROW_27_215 VGND VPWR sky130_fd_sc_hd__tapvpwrvgnd_1
XFILLER_40_201 VGND VGND VPWR VPWR sky130_fd_sc_hd__fill_1
XTAP_TAPCELL_ROW_10_137 VGND VPWR sky130_fd_sc_hd__tapvpwrvgnd_1
XFILLER_4_113 VPWR VGND VPWR VGND sky130_ef_sc_hd__decap_12
X_656_ clknet_4_2_0_wclk _103_ VGND VGND VPWR VPWR bram.mem\[3\]\[7\] sky130_fd_sc_hd__dfxtp_1
XFILLER_16_231 VGND VGND VPWR VPWR sky130_fd_sc_hd__decap_3
XFILLER_16_253 VGND VGND VPWR VPWR sky130_fd_sc_hd__decap_4
X_587_ clknet_4_11_0_wclk _043_ VGND VGND VPWR VPWR bram.mem\[11\]\[3\] sky130_fd_sc_hd__dfxtp_1
XFILLER_31_223 VGND VGND VPWR VPWR sky130_fd_sc_hd__fill_1
XFILLER_3_190 VPWR VGND VPWR VGND sky130_ef_sc_hd__decap_12
XTAP_TAPCELL_ROW_32_240 VGND VPWR sky130_fd_sc_hd__tapvpwrvgnd_1
X_441_ net9 bram.mem\[7\]\[6\] _242_ VGND VGND VPWR VPWR _062_ sky130_fd_sc_hd__mux2_1
X_510_ net6 bram.mem\[15\]\[3\] _204_ VGND VGND VPWR VPWR _123_ sky130_fd_sc_hd__mux2_1
XFILLER_38_89 VGND VGND VPWR VPWR sky130_fd_sc_hd__fill_1
XFILLER_9_249 VGND VGND VPWR VPWR sky130_fd_sc_hd__decap_8
X_372_ bram.mem\[12\]\[3\] bram.mem\[13\]\[3\] bram.mem\[14\]\[3\] bram.mem\[15\]\[3\]
+ bram.raddr\[0\] bram.raddr\[1\] VGND VGND VPWR VPWR _229_ sky130_fd_sc_hd__mux4_1
XFILLER_0_193 VGND VGND VPWR VPWR sky130_fd_sc_hd__decap_3
X_639_ clknet_4_2_0_wclk _086_ VGND VGND VPWR VPWR bram.mem\[5\]\[6\] sky130_fd_sc_hd__dfxtp_1
X_424_ bram.waddr\[0\] bram.waddr\[1\] net23 _234_ VGND VGND VPWR VPWR _240_ sky130_fd_sc_hd__and4b_4
X_286_ _136_ _166_ bram.raddr\[3\] VGND VGND VPWR VPWR _167_ sky130_fd_sc_hd__o21a_1
X_355_ _136_ _213_ VGND VGND VPWR VPWR _214_ sky130_fd_sc_hd__or2_1
Xinput6 wdata[3] VGND VGND VPWR VPWR net6 sky130_fd_sc_hd__clkbuf_4
XFILLER_10_27 VGND VGND VPWR VPWR sky130_fd_sc_hd__fill_1
XFILLER_27_167 VGND VGND VPWR VPWR sky130_fd_sc_hd__fill_1
XFILLER_35_57 VGND VGND VPWR VPWR sky130_fd_sc_hd__decap_3
XPHY_EDGE_ROW_14_Right_14 VGND VGND VPWR VPWR sky130_fd_sc_hd__decap_3
XFILLER_2_233 VPWR VGND VPWR VGND sky130_ef_sc_hd__decap_12
XPHY_EDGE_ROW_23_Right_23 VGND VGND VPWR VPWR sky130_fd_sc_hd__decap_3
X_338_ bram.waddr\[2\] _201_ VGND VGND VPWR VPWR u_wrptr_handler.g_wptr_next\[1\]
+ sky130_fd_sc_hd__xnor2_1
X_407_ bram.mem\[12\]\[0\] net3 _238_ VGND VGND VPWR VPWR _032_ sky130_fd_sc_hd__mux2_1
XPHY_EDGE_ROW_32_Right_32 VGND VGND VPWR VPWR sky130_fd_sc_hd__decap_3
X_269_ bram.mem\[12\]\[5\] bram.mem\[13\]\[5\] bram.mem\[14\]\[5\] bram.mem\[15\]\[5\]
+ bram.raddr\[0\] bram.raddr\[1\] VGND VGND VPWR VPWR _152_ sky130_fd_sc_hd__mux4_1
XPHY_EDGE_ROW_41_Right_41 VGND VGND VPWR VPWR sky130_fd_sc_hd__decap_3
XFILLER_21_15 VGND VGND VPWR VPWR sky130_fd_sc_hd__decap_6
XFILLER_21_37 VPWR VGND VPWR VGND sky130_ef_sc_hd__decap_12
XFILLER_11_70 VGND VGND VPWR VPWR sky130_fd_sc_hd__decap_4
XTAP_TAPCELL_ROW_16_165 VGND VPWR sky130_fd_sc_hd__tapvpwrvgnd_1
XFILLER_29_229 VGND VGND VPWR VPWR sky130_fd_sc_hd__fill_1
XTAP_TAPCELL_ROW_39_268 VGND VPWR sky130_fd_sc_hd__tapvpwrvgnd_1
XFILLER_20_184 VGND VGND VPWR VPWR sky130_fd_sc_hd__decap_6
XFILLER_43_221 VGND VGND VPWR VPWR sky130_fd_sc_hd__decap_3
X_672_ clknet_4_2_0_wclk _110_ VGND VGND VPWR VPWR bram.mem\[4\]\[6\] sky130_fd_sc_hd__dfxtp_1
XTAP_TAPCELL_ROW_21_190 VGND VPWR sky130_fd_sc_hd__tapvpwrvgnd_1
XPHY_EDGE_ROW_14_Left_58 VGND VGND VPWR VPWR sky130_fd_sc_hd__decap_3
XFILLER_19_251 VGND VGND VPWR VPWR sky130_fd_sc_hd__decap_6
XTAP_TAPCELL_ROW_4_114 VGND VPWR sky130_fd_sc_hd__tapvpwrvgnd_1
XPHY_EDGE_ROW_4_Right_4 VGND VGND VPWR VPWR sky130_fd_sc_hd__decap_3
XTAP_TAPCELL_ROW_27_216 VGND VPWR sky130_fd_sc_hd__tapvpwrvgnd_1
XFILLER_43_57 VPWR VGND VPWR VGND sky130_ef_sc_hd__decap_12
XTAP_TAPCELL_ROW_10_138 VGND VPWR sky130_fd_sc_hd__tapvpwrvgnd_1
XFILLER_4_125 VPWR VGND VPWR VGND sky130_ef_sc_hd__decap_12
XFILLER_4_103 VGND VGND VPWR VPWR sky130_fd_sc_hd__fill_1
XFILLER_4_29 VPWR VGND VPWR VGND sky130_ef_sc_hd__decap_12
X_655_ clknet_4_2_0_wclk _102_ VGND VGND VPWR VPWR bram.mem\[3\]\[6\] sky130_fd_sc_hd__dfxtp_1
X_586_ clknet_4_8_0_wclk _042_ VGND VGND VPWR VPWR bram.mem\[11\]\[2\] sky130_fd_sc_hd__dfxtp_1
XFILLER_33_90 VGND VGND VPWR VPWR sky130_fd_sc_hd__decap_8
X_440_ net8 bram.mem\[7\]\[5\] _242_ VGND VGND VPWR VPWR _061_ sky130_fd_sc_hd__mux2_1
X_371_ bram.raddr\[2\] _227_ VGND VGND VPWR VPWR _228_ sky130_fd_sc_hd__or2_1
XFILLER_0_150 VPWR VGND VPWR VGND sky130_ef_sc_hd__decap_12
X_638_ clknet_4_1_0_wclk _085_ VGND VGND VPWR VPWR bram.mem\[5\]\[5\] sky130_fd_sc_hd__dfxtp_1
X_569_ clknet_4_15_0_wclk _025_ VGND VGND VPWR VPWR bram.mem\[13\]\[1\] sky130_fd_sc_hd__dfxtp_1
XFILLER_6_209 VPWR VGND VPWR VGND sky130_ef_sc_hd__decap_12
XPHY_EDGE_ROW_17_Left_61 VGND VGND VPWR VPWR sky130_fd_sc_hd__decap_3
X_354_ bram.mem\[12\]\[1\] bram.mem\[13\]\[1\] bram.mem\[14\]\[1\] bram.mem\[15\]\[1\]
+ bram.raddr\[0\] bram.raddr\[1\] VGND VGND VPWR VPWR _213_ sky130_fd_sc_hd__mux4_1
X_423_ net10 bram.mem\[11\]\[7\] _239_ VGND VGND VPWR VPWR _047_ sky130_fd_sc_hd__mux2_1
X_285_ bram.mem\[12\]\[7\] bram.mem\[13\]\[7\] bram.mem\[14\]\[7\] bram.mem\[15\]\[7\]
+ bram.raddr\[0\] bram.raddr\[1\] VGND VGND VPWR VPWR _166_ sky130_fd_sc_hd__mux4_1
Xinput7 wdata[4] VGND VGND VPWR VPWR net7 sky130_fd_sc_hd__clkbuf_4
XFILLER_36_113 VGND VGND VPWR VPWR sky130_fd_sc_hd__fill_1
XFILLER_19_15 VPWR VGND VPWR VGND sky130_ef_sc_hd__decap_12
XFILLER_27_113 VPWR VGND VPWR VGND sky130_ef_sc_hd__decap_12
XFILLER_35_25 VGND VGND VPWR VPWR sky130_fd_sc_hd__decap_4
XPHY_EDGE_ROW_2_Left_46 VGND VGND VPWR VPWR sky130_fd_sc_hd__decap_3
XFILLER_4_3 VPWR VGND VPWR VGND sky130_ef_sc_hd__decap_12
XFILLER_2_245 VGND VGND VPWR VPWR sky130_fd_sc_hd__decap_6
X_337_ bram.waddr\[2\] _200_ VGND VGND VPWR VPWR u_wrptr_handler.b_wptr_next\[2\]
+ sky130_fd_sc_hd__xor2_1
X_406_ bram.waddr\[0\] bram.waddr\[1\] net23 _203_ VGND VGND VPWR VPWR _238_ sky130_fd_sc_hd__and4bb_4
XFILLER_33_138 VGND VGND VPWR VPWR sky130_fd_sc_hd__decap_3
X_268_ bram.raddr\[2\] _150_ VGND VGND VPWR VPWR _151_ sky130_fd_sc_hd__or2_1
XFILLER_37_3 VGND VGND VPWR VPWR sky130_fd_sc_hd__decap_4
XFILLER_21_49 VGND VGND VPWR VPWR sky130_fd_sc_hd__decap_6
XFILLER_32_171 VGND VGND VPWR VPWR sky130_fd_sc_hd__decap_8
XFILLER_38_208 VPWR VGND VPWR VGND sky130_ef_sc_hd__decap_12
XTAP_TAPCELL_ROW_16_166 VGND VPWR sky130_fd_sc_hd__tapvpwrvgnd_1
Xinput10 wdata[7] VGND VGND VPWR VPWR net10 sky130_fd_sc_hd__clkbuf_4
Xclkbuf_4_6_0_wclk clknet_0_wclk VGND VGND VPWR VPWR clknet_4_6_0_wclk sky130_fd_sc_hd__clkbuf_8
XTAP_TAPCELL_ROW_39_269 VGND VPWR sky130_fd_sc_hd__tapvpwrvgnd_1
XFILLER_16_27 VGND VGND VPWR VPWR sky130_fd_sc_hd__fill_1
XFILLER_20_141 VPWR VGND VPWR VGND sky130_ef_sc_hd__decap_12
X_671_ clknet_4_4_0_wclk _109_ VGND VGND VPWR VPWR bram.mem\[4\]\[5\] sky130_fd_sc_hd__dfxtp_1
Xclkbuf_4_14_0_wclk clknet_0_wclk VGND VGND VPWR VPWR clknet_4_14_0_wclk sky130_fd_sc_hd__clkbuf_8
XFILLER_27_26 VGND VGND VPWR VPWR sky130_fd_sc_hd__fill_1
XFILLER_27_48 VGND VGND VPWR VPWR sky130_fd_sc_hd__decap_8
XTAP_TAPCELL_ROW_27_217 VGND VPWR sky130_fd_sc_hd__tapvpwrvgnd_1
XFILLER_43_69 VPWR VGND VPWR VGND sky130_ef_sc_hd__decap_12
XTAP_TAPCELL_ROW_10_139 VGND VPWR sky130_fd_sc_hd__tapvpwrvgnd_1
XTAP_TAPCELL_ROW_35_250 VGND VPWR sky130_fd_sc_hd__tapvpwrvgnd_1
XFILLER_4_137 VGND VGND VPWR VPWR sky130_fd_sc_hd__decap_3
X_654_ clknet_4_1_0_wclk _101_ VGND VGND VPWR VPWR bram.mem\[3\]\[5\] sky130_fd_sc_hd__dfxtp_1
XPHY_EDGE_ROW_31_Left_75 VGND VGND VPWR VPWR sky130_fd_sc_hd__decap_3
XFILLER_31_225 VGND VGND VPWR VPWR sky130_fd_sc_hd__decap_6
X_585_ clknet_4_15_0_wclk _041_ VGND VGND VPWR VPWR bram.mem\[11\]\[1\] sky130_fd_sc_hd__dfxtp_1
XFILLER_22_214 VPWR VGND VPWR VGND sky130_ef_sc_hd__decap_12
XFILLER_1_129 VGND VGND VPWR VPWR sky130_fd_sc_hd__decap_3
XFILLER_13_225 VPWR VGND VPWR VGND sky130_ef_sc_hd__decap_12
X_370_ bram.mem\[8\]\[3\] bram.mem\[9\]\[3\] bram.mem\[10\]\[3\] bram.mem\[11\]\[3\]
+ bram.raddr\[0\] bram.raddr\[1\] VGND VGND VPWR VPWR _227_ sky130_fd_sc_hd__mux4_1
XFILLER_0_162 VGND VGND VPWR VPWR sky130_fd_sc_hd__decap_6
X_637_ clknet_4_1_0_wclk _084_ VGND VGND VPWR VPWR bram.mem\[5\]\[4\] sky130_fd_sc_hd__dfxtp_1
X_499_ net3 bram.mem\[1\]\[0\] _250_ VGND VGND VPWR VPWR _112_ sky130_fd_sc_hd__mux2_1
X_568_ clknet_4_12_0_wclk _024_ VGND VGND VPWR VPWR bram.mem\[13\]\[0\] sky130_fd_sc_hd__dfxtp_1
XFILLER_8_251 VGND VGND VPWR VPWR sky130_fd_sc_hd__fill_1
XFILLER_39_122 VGND VGND VPWR VPWR sky130_fd_sc_hd__decap_4
XFILLER_40_59 VGND VGND VPWR VPWR sky130_fd_sc_hd__fill_1
X_353_ _207_ _209_ _212_ _137_ VGND VGND VPWR VPWR _000_ sky130_fd_sc_hd__a22o_1
X_284_ bram.raddr\[2\] _164_ VGND VGND VPWR VPWR _165_ sky130_fd_sc_hd__or2_1
X_422_ net9 bram.mem\[11\]\[6\] _239_ VGND VGND VPWR VPWR _046_ sky130_fd_sc_hd__mux2_1
XFILLER_14_82 VGND VGND VPWR VPWR sky130_fd_sc_hd__fill_2
Xinput8 wdata[5] VGND VGND VPWR VPWR net8 sky130_fd_sc_hd__clkbuf_4
XFILLER_36_136 VGND VGND VPWR VPWR sky130_fd_sc_hd__decap_4
XFILLER_36_147 VGND VGND VPWR VPWR sky130_fd_sc_hd__decap_6
XFILLER_10_29 VGND VGND VPWR VPWR sky130_fd_sc_hd__decap_8
XFILLER_19_27 VGND VGND VPWR VPWR sky130_fd_sc_hd__decap_8
XFILLER_27_125 VPWR VGND VPWR VGND sky130_ef_sc_hd__decap_12
XFILLER_35_15 VGND VGND VPWR VPWR sky130_fd_sc_hd__fill_1
X_336_ bram.waddr\[0\] bram.waddr\[1\] net23 bram.waddr\[2\] VGND VGND VPWR VPWR _202_
+ sky130_fd_sc_hd__a31o_1
X_267_ bram.mem\[8\]\[5\] bram.mem\[9\]\[5\] bram.mem\[10\]\[5\] bram.mem\[11\]\[5\]
+ bram.raddr\[0\] bram.raddr\[1\] VGND VGND VPWR VPWR _150_ sky130_fd_sc_hd__mux4_1
X_405_ net10 bram.mem\[13\]\[7\] _237_ VGND VGND VPWR VPWR _031_ sky130_fd_sc_hd__mux2_1
XFILLER_2_85 VGND VGND VPWR VPWR sky130_fd_sc_hd__decap_6
XFILLER_24_139 VGND VGND VPWR VPWR sky130_fd_sc_hd__fill_1
XFILLER_15_128 VGND VGND VPWR VPWR sky130_fd_sc_hd__fill_1
XFILLER_11_83 VPWR VGND VPWR VGND sky130_ef_sc_hd__decap_12
XTAP_TAPCELL_ROW_16_167 VGND VPWR sky130_fd_sc_hd__tapvpwrvgnd_1
XFILLER_21_109 VGND VGND VPWR VPWR sky130_fd_sc_hd__decap_3
XFILLER_14_194 VGND VGND VPWR VPWR sky130_fd_sc_hd__fill_2
Xinput11 wen VGND VGND VPWR VPWR net11 sky130_fd_sc_hd__clkbuf_1
X_319_ bram.raddr\[2\] _192_ VGND VGND VPWR VPWR _194_ sky130_fd_sc_hd__and2_1
XFILLER_29_209 VPWR VGND VPWR VGND sky130_ef_sc_hd__decap_12
XFILLER_20_153 VGND VGND VPWR VPWR sky130_fd_sc_hd__decap_4
XFILLER_20_197 VPWR VGND VPWR VGND sky130_ef_sc_hd__decap_12
X_670_ clknet_4_1_0_wclk _108_ VGND VGND VPWR VPWR bram.mem\[4\]\[4\] sky130_fd_sc_hd__dfxtp_1
XTAP_TAPCELL_ROW_7_124 VGND VPWR sky130_fd_sc_hd__tapvpwrvgnd_1
XFILLER_28_253 VGND VGND VPWR VPWR sky130_fd_sc_hd__decap_4
XFILLER_7_113 VGND VGND VPWR VPWR sky130_fd_sc_hd__decap_8
XFILLER_43_15 VPWR VGND VPWR VGND sky130_ef_sc_hd__decap_12
XFILLER_25_256 VGND VGND VPWR VPWR sky130_fd_sc_hd__fill_1
XTAP_TAPCELL_ROW_35_251 VGND VPWR sky130_fd_sc_hd__tapvpwrvgnd_1
XFILLER_40_248 VGND VGND VPWR VPWR sky130_fd_sc_hd__decap_4
X_653_ clknet_4_1_0_wclk _100_ VGND VGND VPWR VPWR bram.mem\[3\]\[4\] sky130_fd_sc_hd__dfxtp_1
X_584_ clknet_4_12_0_wclk _040_ VGND VGND VPWR VPWR bram.mem\[11\]\[0\] sky130_fd_sc_hd__dfxtp_1
XFILLER_31_215 VGND VGND VPWR VPWR sky130_fd_sc_hd__decap_8
XFILLER_12_3 VGND VGND VPWR VPWR sky130_fd_sc_hd__decap_8
XFILLER_22_226 VPWR VGND VPWR VGND sky130_ef_sc_hd__decap_12
XFILLER_1_108 VGND VGND VPWR VPWR sky130_fd_sc_hd__decap_4
XFILLER_13_237 VPWR VGND VPWR VGND sky130_ef_sc_hd__decap_12
XFILLER_0_185 VGND VGND VPWR VPWR sky130_fd_sc_hd__decap_8
X_636_ clknet_4_3_0_wclk _083_ VGND VGND VPWR VPWR bram.mem\[5\]\[3\] sky130_fd_sc_hd__dfxtp_1
X_567_ clknet_4_8_0_wclk _023_ VGND VGND VPWR VPWR bram.mem\[14\]\[7\] sky130_fd_sc_hd__dfxtp_1
X_498_ bram.waddr\[1\] net23 _244_ bram.waddr\[0\] VGND VGND VPWR VPWR _250_ sky130_fd_sc_hd__nand4b_4
XFILLER_5_52 VGND VGND VPWR VPWR sky130_fd_sc_hd__decap_4
XFILLER_39_167 VGND VGND VPWR VPWR sky130_fd_sc_hd__fill_1
XFILLER_39_178 VGND VGND VPWR VPWR sky130_fd_sc_hd__decap_4
XFILLER_40_27 VGND VGND VPWR VPWR sky130_fd_sc_hd__fill_1
X_421_ net8 bram.mem\[11\]\[5\] _239_ VGND VGND VPWR VPWR _045_ sky130_fd_sc_hd__mux2_1
Xclkbuf_1_1__f_rclk clknet_0_rclk VGND VGND VPWR VPWR clknet_1_1__leaf_rclk sky130_fd_sc_hd__clkbuf_16
X_352_ _210_ _211_ bram.raddr\[2\] VGND VGND VPWR VPWR _212_ sky130_fd_sc_hd__mux2_1
X_283_ bram.mem\[8\]\[7\] bram.mem\[9\]\[7\] bram.mem\[10\]\[7\] bram.mem\[11\]\[7\]
+ bram.raddr\[0\] bram.raddr\[1\] VGND VGND VPWR VPWR _164_ sky130_fd_sc_hd__mux4_1
XTAP_TAPCELL_ROW_1_97 VGND VPWR sky130_fd_sc_hd__tapvpwrvgnd_1
Xinput9 wdata[6] VGND VGND VPWR VPWR net9 sky130_fd_sc_hd__clkbuf_4
X_619_ clknet_4_6_0_wclk _075_ VGND VGND VPWR VPWR bram.mem\[0\]\[3\] sky130_fd_sc_hd__dfxtp_1
XFILLER_42_107 VPWR VGND VPWR VGND sky130_ef_sc_hd__decap_12
XFILLER_27_104 VGND VGND VPWR VPWR sky130_fd_sc_hd__decap_8
XFILLER_27_137 VGND VGND VPWR VPWR sky130_fd_sc_hd__decap_4
X_404_ net9 bram.mem\[13\]\[6\] _237_ VGND VGND VPWR VPWR _030_ sky130_fd_sc_hd__mux2_1
X_335_ bram.waddr\[1\] _199_ VGND VGND VPWR VPWR u_wrptr_handler.g_wptr_next\[0\]
+ sky130_fd_sc_hd__xnor2_1
X_266_ _144_ _146_ _149_ _137_ VGND VGND VPWR VPWR _004_ sky130_fd_sc_hd__a22o_1
XPHY_EDGE_ROW_10_Right_10 VGND VGND VPWR VPWR sky130_fd_sc_hd__decap_3
XFILLER_24_118 VGND VGND VPWR VPWR sky130_fd_sc_hd__fill_1
XFILLER_32_195 VGND VGND VPWR VPWR sky130_fd_sc_hd__fill_1
XFILLER_15_107 VGND VGND VPWR VPWR sky130_fd_sc_hd__decap_4
XFILLER_11_95 VGND VGND VPWR VPWR sky130_fd_sc_hd__fill_2
XTAP_TAPCELL_ROW_16_168 VGND VPWR sky130_fd_sc_hd__tapvpwrvgnd_1
Xinput12 wrst_n VGND VGND VPWR VPWR net12 sky130_fd_sc_hd__clkbuf_8
X_318_ bram.raddr\[1\] _191_ VGND VGND VPWR VPWR u_rptr_handler.g_rptr_next\[0\] sky130_fd_sc_hd__xnor2_1
XFILLER_42_3 VPWR VGND VPWR VGND sky130_ef_sc_hd__decap_12
XTAP_TAPCELL_ROW_7_125 VGND VPWR sky130_fd_sc_hd__tapvpwrvgnd_1
XFILLER_11_187 VPWR VGND VPWR VGND sky130_ef_sc_hd__decap_12
XFILLER_43_27 VGND VGND VPWR VPWR sky130_fd_sc_hd__fill_1
XTAP_TAPCELL_ROW_35_252 VGND VPWR sky130_fd_sc_hd__tapvpwrvgnd_1
XFILLER_17_50 VGND VGND VPWR VPWR sky130_fd_sc_hd__decap_6
X_652_ clknet_4_3_0_wclk _099_ VGND VGND VPWR VPWR bram.mem\[3\]\[3\] sky130_fd_sc_hd__dfxtp_1
X_583_ clknet_4_9_0_wclk _039_ VGND VGND VPWR VPWR bram.mem\[12\]\[7\] sky130_fd_sc_hd__dfxtp_1
XTAP_TAPCELL_ROW_41_277 VGND VPWR sky130_fd_sc_hd__tapvpwrvgnd_1
XPHY_EDGE_ROW_8_Right_8 VGND VGND VPWR VPWR sky130_fd_sc_hd__decap_3
XPHY_EDGE_ROW_39_Right_39 VGND VGND VPWR VPWR sky130_fd_sc_hd__decap_3
XFILLER_38_38 VPWR VGND VPWR VGND sky130_ef_sc_hd__decap_12
XFILLER_13_249 VGND VGND VPWR VPWR sky130_fd_sc_hd__decap_8
XFILLER_0_197 VPWR VGND VPWR VGND sky130_ef_sc_hd__decap_12
X_635_ clknet_4_0_0_wclk _082_ VGND VGND VPWR VPWR bram.mem\[5\]\[2\] sky130_fd_sc_hd__dfxtp_1
XFILLER_28_93 VGND VGND VPWR VPWR sky130_fd_sc_hd__fill_2
X_566_ clknet_4_10_0_wclk _022_ VGND VGND VPWR VPWR bram.mem\[14\]\[6\] sky130_fd_sc_hd__dfxtp_1
XFILLER_8_253 VGND VGND VPWR VPWR sky130_fd_sc_hd__decap_4
X_497_ bram.mem\[4\]\[7\] net10 _249_ VGND VGND VPWR VPWR _111_ sky130_fd_sc_hd__mux2_1
XFILLER_5_42 VGND VGND VPWR VPWR sky130_fd_sc_hd__fill_1
XFILLER_24_29 VGND VGND VPWR VPWR sky130_fd_sc_hd__decap_6
X_351_ bram.mem\[4\]\[0\] bram.mem\[5\]\[0\] bram.mem\[6\]\[0\] bram.mem\[7\]\[0\]
+ bram.raddr\[0\] bram.raddr\[1\] VGND VGND VPWR VPWR _211_ sky130_fd_sc_hd__mux4_1
X_420_ net7 bram.mem\[11\]\[4\] _239_ VGND VGND VPWR VPWR _044_ sky130_fd_sc_hd__mux2_1
X_282_ _158_ _160_ _163_ _137_ VGND VGND VPWR VPWR _006_ sky130_fd_sc_hd__a22o_1
XFILLER_5_223 VGND VGND VPWR VPWR sky130_fd_sc_hd__fill_1
XTAP_TAPCELL_ROW_1_98 VGND VPWR sky130_fd_sc_hd__tapvpwrvgnd_1
X_618_ clknet_4_0_0_wclk _074_ VGND VGND VPWR VPWR bram.mem\[0\]\[2\] sky130_fd_sc_hd__dfxtp_1
X_549_ clknet_1_0__leaf_rclk _007_ VGND VGND VPWR VPWR net22 sky130_fd_sc_hd__dfxtp_1
XFILLER_42_119 VGND VGND VPWR VPWR sky130_fd_sc_hd__decap_4
XFILLER_18_149 VGND VGND VPWR VPWR sky130_fd_sc_hd__fill_1
X_334_ _200_ _201_ VGND VGND VPWR VPWR u_wrptr_handler.b_wptr_next\[1\] sky130_fd_sc_hd__nor2_1
XFILLER_25_50 VGND VGND VPWR VPWR sky130_fd_sc_hd__decap_6
XFILLER_25_61 VGND VGND VPWR VPWR sky130_fd_sc_hd__fill_1
XFILLER_25_83 VGND VGND VPWR VPWR sky130_fd_sc_hd__decap_4
X_403_ net8 bram.mem\[13\]\[5\] _237_ VGND VGND VPWR VPWR _029_ sky130_fd_sc_hd__mux2_1
XFILLER_33_108 VGND VGND VPWR VPWR sky130_fd_sc_hd__decap_4
X_265_ _147_ _148_ bram.raddr\[2\] VGND VGND VPWR VPWR _149_ sky130_fd_sc_hd__mux2_1
XFILLER_41_185 VPWR VGND VPWR VGND sky130_ef_sc_hd__decap_12
XFILLER_32_141 VGND VGND VPWR VPWR sky130_fd_sc_hd__decap_8
XFILLER_2_3 VPWR VGND VPWR VGND sky130_ef_sc_hd__decap_12
XFILLER_14_130 VGND VGND VPWR VPWR sky130_fd_sc_hd__fill_1
XFILLER_14_141 VGND VGND VPWR VPWR sky130_fd_sc_hd__fill_1
XFILLER_14_163 VGND VGND VPWR VPWR sky130_fd_sc_hd__decap_6
X_317_ _192_ _193_ VGND VGND VPWR VPWR u_rptr_handler.b_rptr_next\[1\] sky130_fd_sc_hd__nor2_1
XFILLER_35_3 VPWR VGND VPWR VGND sky130_ef_sc_hd__decap_12
XTAP_TAPCELL_ROW_7_126 VGND VPWR sky130_fd_sc_hd__tapvpwrvgnd_1
XFILLER_43_225 VPWR VGND VPWR VGND sky130_ef_sc_hd__decap_12
XFILLER_28_244 VGND VGND VPWR VPWR sky130_fd_sc_hd__decap_8
XFILLER_7_137 VGND VGND VPWR VPWR sky130_fd_sc_hd__decap_6
XFILLER_11_166 VGND VGND VPWR VPWR sky130_fd_sc_hd__fill_2
XFILLER_11_199 VPWR VGND VPWR VGND sky130_ef_sc_hd__decap_12
XFILLER_19_222 VGND VGND VPWR VPWR sky130_fd_sc_hd__fill_2
XFILLER_19_233 VGND VGND VPWR VPWR sky130_fd_sc_hd__fill_1
XFILLER_8_53 VGND VGND VPWR VPWR sky130_fd_sc_hd__decap_6
XTAP_TAPCELL_ROW_12_150 VGND VPWR sky130_fd_sc_hd__tapvpwrvgnd_1
XFILLER_25_225 VPWR VGND VPWR VGND sky130_ef_sc_hd__decap_12
XTAP_TAPCELL_ROW_35_253 VGND VPWR sky130_fd_sc_hd__tapvpwrvgnd_1
XPHY_EDGE_ROW_9_Left_53 VGND VGND VPWR VPWR sky130_fd_sc_hd__decap_3
X_651_ clknet_4_0_0_wclk _098_ VGND VGND VPWR VPWR bram.mem\[3\]\[2\] sky130_fd_sc_hd__dfxtp_1
X_582_ clknet_4_11_0_wclk _038_ VGND VGND VPWR VPWR bram.mem\[12\]\[6\] sky130_fd_sc_hd__dfxtp_1
XTAP_TAPCELL_ROW_41_278 VGND VPWR sky130_fd_sc_hd__tapvpwrvgnd_1
XPHY_EDGE_ROW_35_Left_79 VGND VGND VPWR VPWR sky130_fd_sc_hd__decap_3
XFILLER_0_121 VGND VGND VPWR VPWR sky130_fd_sc_hd__decap_3
X_634_ clknet_4_4_0_wclk _081_ VGND VGND VPWR VPWR bram.mem\[5\]\[1\] sky130_fd_sc_hd__dfxtp_1
XFILLER_28_83 VGND VGND VPWR VPWR sky130_fd_sc_hd__fill_1
X_496_ bram.mem\[4\]\[6\] net9 _249_ VGND VGND VPWR VPWR _110_ sky130_fd_sc_hd__mux2_1
X_565_ clknet_4_9_0_wclk _021_ VGND VGND VPWR VPWR bram.mem\[14\]\[5\] sky130_fd_sc_hd__dfxtp_1
XFILLER_8_221 VPWR VGND VPWR VGND sky130_ef_sc_hd__decap_12
XFILLER_5_21 VGND VGND VPWR VPWR sky130_fd_sc_hd__fill_1
XFILLER_10_209 VPWR VGND VPWR VGND sky130_ef_sc_hd__decap_12
XFILLER_40_29 VPWR VGND VPWR VGND sky130_ef_sc_hd__decap_12
X_350_ bram.mem\[0\]\[0\] bram.mem\[1\]\[0\] bram.mem\[2\]\[0\] bram.mem\[3\]\[0\]
+ bram.raddr\[0\] bram.raddr\[1\] VGND VGND VPWR VPWR _210_ sky130_fd_sc_hd__mux4_1
X_281_ _161_ _162_ bram.raddr\[2\] VGND VGND VPWR VPWR _163_ sky130_fd_sc_hd__mux2_1
XTAP_TAPCELL_ROW_1_99 VGND VPWR sky130_fd_sc_hd__tapvpwrvgnd_1
X_617_ clknet_4_7_0_wclk _073_ VGND VGND VPWR VPWR bram.mem\[0\]\[1\] sky130_fd_sc_hd__dfxtp_1
X_548_ clknet_1_0__leaf_rclk _006_ VGND VGND VPWR VPWR net21 sky130_fd_sc_hd__dfxtp_1
X_479_ bram.mem\[6\]\[7\] net10 _247_ VGND VGND VPWR VPWR _095_ sky130_fd_sc_hd__mux2_1
XFILLER_35_183 VGND VGND VPWR VPWR sky130_fd_sc_hd__decap_3
XFILLER_18_139 VGND VGND VPWR VPWR sky130_fd_sc_hd__fill_1
X_264_ bram.mem\[4\]\[4\] bram.mem\[5\]\[4\] bram.mem\[6\]\[4\] bram.mem\[7\]\[4\]
+ bram.raddr\[0\] bram.raddr\[1\] VGND VGND VPWR VPWR _148_ sky130_fd_sc_hd__mux4_1
X_333_ bram.waddr\[0\] net23 bram.waddr\[1\] VGND VGND VPWR VPWR _201_ sky130_fd_sc_hd__a21oi_1
XFILLER_26_172 VPWR VGND VPWR VGND sky130_ef_sc_hd__decap_12
X_402_ net7 bram.mem\[13\]\[4\] _237_ VGND VGND VPWR VPWR _028_ sky130_fd_sc_hd__mux2_1
XFILLER_41_197 VGND VGND VPWR VPWR sky130_fd_sc_hd__decap_8
XPHY_EDGE_ROW_38_Left_82 VGND VGND VPWR VPWR sky130_fd_sc_hd__decap_3
XPHY_EDGE_ROW_22_Left_66 VGND VGND VPWR VPWR sky130_fd_sc_hd__decap_3
XFILLER_37_7 VGND VGND VPWR VPWR sky130_fd_sc_hd__fill_1
XTAP_TAPCELL_ROW_19_178 VGND VPWR sky130_fd_sc_hd__tapvpwrvgnd_1
Xclkbuf_4_1_0_wclk clknet_0_wclk VGND VGND VPWR VPWR clknet_4_1_0_wclk sky130_fd_sc_hd__clkbuf_8
XFILLER_36_94 VGND VGND VPWR VPWR sky130_fd_sc_hd__decap_4
X_316_ bram.raddr\[0\] _189_ bram.raddr\[1\] VGND VGND VPWR VPWR _193_ sky130_fd_sc_hd__a21oi_1
XFILLER_28_3 VPWR VGND VPWR VGND sky130_ef_sc_hd__decap_12
XFILLER_37_223 VGND VGND VPWR VPWR sky130_fd_sc_hd__fill_1
XTAP_TAPCELL_ROW_7_127 VGND VPWR sky130_fd_sc_hd__tapvpwrvgnd_1
XFILLER_43_237 VPWR VGND VPWR VGND sky130_ef_sc_hd__decap_12
XFILLER_22_85 VGND VGND VPWR VPWR sky130_fd_sc_hd__fill_1
XFILLER_6_171 VPWR VGND VPWR VGND sky130_ef_sc_hd__decap_12
XFILLER_25_204 VPWR VGND VPWR VGND sky130_ef_sc_hd__decap_12
XFILLER_25_237 VGND VGND VPWR VPWR sky130_fd_sc_hd__decap_3
XFILLER_43_29 VPWR VGND VPWR VGND sky130_ef_sc_hd__decap_12
X_650_ clknet_4_6_0_wclk _097_ VGND VGND VPWR VPWR bram.mem\[3\]\[1\] sky130_fd_sc_hd__dfxtp_1
XFILLER_17_85 VGND VGND VPWR VPWR sky130_fd_sc_hd__decap_8
X_581_ clknet_4_12_0_wclk _037_ VGND VGND VPWR VPWR bram.mem\[12\]\[5\] sky130_fd_sc_hd__dfxtp_1
XTAP_TAPCELL_ROW_26_210 VGND VPWR sky130_fd_sc_hd__tapvpwrvgnd_1
XTAP_TAPCELL_ROW_41_279 VGND VPWR sky130_fd_sc_hd__tapvpwrvgnd_1
XFILLER_0_111 VGND VGND VPWR VPWR sky130_fd_sc_hd__fill_1
XFILLER_0_133 VGND VGND VPWR VPWR sky130_fd_sc_hd__decap_6
X_633_ clknet_4_4_0_wclk _080_ VGND VGND VPWR VPWR bram.mem\[5\]\[0\] sky130_fd_sc_hd__dfxtp_1
X_495_ bram.mem\[4\]\[5\] net8 _249_ VGND VGND VPWR VPWR _109_ sky130_fd_sc_hd__mux2_1
XFILLER_12_251 VGND VGND VPWR VPWR sky130_fd_sc_hd__fill_1
X_564_ clknet_4_9_0_wclk _020_ VGND VGND VPWR VPWR bram.mem\[14\]\[4\] sky130_fd_sc_hd__dfxtp_1
XFILLER_8_233 VPWR VGND VPWR VGND sky130_ef_sc_hd__decap_12
XFILLER_10_3 VPWR VGND VPWR VGND sky130_ef_sc_hd__decap_12
XFILLER_5_99 VPWR VGND VPWR VGND sky130_ef_sc_hd__decap_12
XFILLER_5_88 VGND VGND VPWR VPWR sky130_fd_sc_hd__fill_2
X_280_ bram.mem\[4\]\[6\] bram.mem\[5\]\[6\] bram.mem\[6\]\[6\] bram.mem\[7\]\[6\]
+ bram.raddr\[0\] bram.raddr\[1\] VGND VGND VPWR VPWR _162_ sky130_fd_sc_hd__mux4_1
XFILLER_5_225 VPWR VGND VPWR VGND sky130_ef_sc_hd__decap_12
XFILLER_30_41 VGND VGND VPWR VPWR sky130_fd_sc_hd__decap_6
XFILLER_30_85 VGND VGND VPWR VPWR sky130_fd_sc_hd__fill_2
X_616_ clknet_4_5_0_wclk _072_ VGND VGND VPWR VPWR bram.mem\[0\]\[0\] sky130_fd_sc_hd__dfxtp_1
X_547_ clknet_1_0__leaf_rclk _005_ VGND VGND VPWR VPWR net20 sky130_fd_sc_hd__dfxtp_1
XFILLER_36_107 VGND VGND VPWR VPWR sky130_fd_sc_hd__decap_6
X_478_ bram.mem\[6\]\[6\] net9 _247_ VGND VGND VPWR VPWR _094_ sky130_fd_sc_hd__mux2_1
X_401_ net6 bram.mem\[13\]\[3\] _237_ VGND VGND VPWR VPWR _027_ sky130_fd_sc_hd__mux2_1
X_263_ bram.mem\[0\]\[4\] bram.mem\[1\]\[4\] bram.mem\[2\]\[4\] bram.mem\[3\]\[4\]
+ bram.raddr\[0\] bram.raddr\[1\] VGND VGND VPWR VPWR _147_ sky130_fd_sc_hd__mux4_1
X_332_ bram.waddr\[0\] bram.waddr\[1\] _198_ VGND VGND VPWR VPWR _200_ sky130_fd_sc_hd__and3_1
XFILLER_26_184 VPWR VGND VPWR VGND sky130_ef_sc_hd__decap_12
XFILLER_41_143 VPWR VGND VPWR VGND sky130_ef_sc_hd__decap_12
XFILLER_41_51 VGND VGND VPWR VPWR sky130_fd_sc_hd__decap_4
XFILLER_41_84 VGND VGND VPWR VPWR sky130_fd_sc_hd__fill_2
XTAP_TAPCELL_ROW_19_179 VGND VPWR sky130_fd_sc_hd__tapvpwrvgnd_1
XFILLER_11_54 VGND VGND VPWR VPWR sky130_fd_sc_hd__fill_2
X_315_ bram.raddr\[1\] bram.raddr\[0\] _189_ VGND VGND VPWR VPWR _192_ sky130_fd_sc_hd__and3_1
XTAP_TAPCELL_ROW_15_160 VGND VPWR sky130_fd_sc_hd__tapvpwrvgnd_1
XFILLER_20_157 VGND VGND VPWR VPWR sky130_fd_sc_hd__fill_1
XFILLER_43_249 VGND VGND VPWR VPWR sky130_fd_sc_hd__decap_3
XTAP_TAPCELL_ROW_38_263 VGND VPWR sky130_fd_sc_hd__tapvpwrvgnd_1
XFILLER_11_113 VPWR VGND VPWR VGND sky130_ef_sc_hd__decap_12
XFILLER_19_202 VPWR VGND VPWR VGND sky130_ef_sc_hd__decap_12
XFILLER_10_190 VGND VGND VPWR VPWR sky130_fd_sc_hd__decap_6
XFILLER_6_183 VPWR VGND VPWR VGND sky130_ef_sc_hd__decap_12
XFILLER_25_216 VGND VGND VPWR VPWR sky130_fd_sc_hd__decap_8
X_580_ clknet_4_14_0_wclk _036_ VGND VGND VPWR VPWR bram.mem\[12\]\[4\] sky130_fd_sc_hd__dfxtp_1
XTAP_TAPCELL_ROW_26_211 VGND VPWR sky130_fd_sc_hd__tapvpwrvgnd_1
XTAP_TAPCELL_ROW_32_236 VGND VPWR sky130_fd_sc_hd__tapvpwrvgnd_1
XPHY_EDGE_ROW_17_Right_17 VGND VGND VPWR VPWR sky130_fd_sc_hd__decap_3
XFILLER_21_252 VGND VGND VPWR VPWR sky130_fd_sc_hd__decap_4
XPHY_EDGE_ROW_26_Right_26 VGND VGND VPWR VPWR sky130_fd_sc_hd__decap_3
X_632_ clknet_4_13_0_wclk u_wrptr_handler.g_wptr_next\[3\] net12 VGND VGND VPWR VPWR
+ sync_gwptr_to_rd.d1\[3\] sky130_fd_sc_hd__dfrtp_1
XFILLER_28_85 VGND VGND VPWR VPWR sky130_fd_sc_hd__decap_8
X_563_ clknet_4_11_0_wclk _019_ VGND VGND VPWR VPWR bram.mem\[14\]\[3\] sky130_fd_sc_hd__dfxtp_1
XFILLER_8_245 VGND VGND VPWR VPWR sky130_fd_sc_hd__decap_6
X_494_ bram.mem\[4\]\[4\] net7 _249_ VGND VGND VPWR VPWR _108_ sky130_fd_sc_hd__mux2_1
XPHY_EDGE_ROW_35_Right_35 VGND VGND VPWR VPWR sky130_fd_sc_hd__decap_3
XFILLER_14_65 VGND VGND VPWR VPWR sky130_fd_sc_hd__fill_1
XFILLER_5_237 VPWR VGND VPWR VGND sky130_ef_sc_hd__decap_12
X_615_ clknet_4_10_0_wclk _071_ VGND VGND VPWR VPWR bram.mem\[8\]\[7\] sky130_fd_sc_hd__dfxtp_1
X_546_ clknet_1_0__leaf_rclk _004_ VGND VGND VPWR VPWR net19 sky130_fd_sc_hd__dfxtp_1
X_477_ bram.mem\[6\]\[5\] net8 _247_ VGND VGND VPWR VPWR _093_ sky130_fd_sc_hd__mux2_1
X_331_ bram.waddr\[0\] _198_ VGND VGND VPWR VPWR u_wrptr_handler.b_wptr_next\[0\]
+ sky130_fd_sc_hd__xor2_1
X_400_ net5 bram.mem\[13\]\[2\] _237_ VGND VGND VPWR VPWR _026_ sky130_fd_sc_hd__mux2_1
XFILLER_41_111 VGND VGND VPWR VPWR sky130_fd_sc_hd__fill_1
X_262_ bram.raddr\[2\] _145_ bram.raddr\[3\] VGND VGND VPWR VPWR _146_ sky130_fd_sc_hd__o21a_1
XFILLER_41_155 VGND VGND VPWR VPWR sky130_fd_sc_hd__decap_4
XFILLER_2_35 VGND VGND VPWR VPWR sky130_fd_sc_hd__fill_1
X_529_ clknet_4_8_0_wclk _013_ VGND VGND VPWR VPWR bram.mem\[9\]\[5\] sky130_fd_sc_hd__dfxtp_1
XFILLER_32_133 VGND VGND VPWR VPWR sky130_fd_sc_hd__decap_6
XFILLER_23_122 VGND VGND VPWR VPWR sky130_fd_sc_hd__fill_1
X_314_ _190_ _191_ VGND VGND VPWR VPWR u_rptr_handler.b_rptr_next\[0\] sky130_fd_sc_hd__nor2_1
XFILLER_37_203 VPWR VGND VPWR VGND sky130_ef_sc_hd__decap_12
XFILLER_37_225 VPWR VGND VPWR VGND sky130_ef_sc_hd__decap_12
XTAP_TAPCELL_ROW_15_161 VGND VPWR sky130_fd_sc_hd__tapvpwrvgnd_1
XFILLER_28_203 VGND VGND VPWR VPWR sky130_fd_sc_hd__fill_1
XTAP_TAPCELL_ROW_38_264 VGND VPWR sky130_fd_sc_hd__tapvpwrvgnd_1
XFILLER_11_125 VPWR VGND VPWR VGND sky130_ef_sc_hd__decap_12
XFILLER_22_76 VGND VGND VPWR VPWR sky130_fd_sc_hd__decap_8
XFILLER_0_3 VPWR VGND VPWR VGND sky130_ef_sc_hd__decap_12
XFILLER_19_214 VGND VGND VPWR VPWR sky130_fd_sc_hd__decap_8
XFILLER_19_225 VGND VGND VPWR VPWR sky130_fd_sc_hd__decap_8
XFILLER_34_239 VGND VGND VPWR VPWR sky130_fd_sc_hd__fill_2
XFILLER_6_195 VGND VGND VPWR VPWR sky130_fd_sc_hd__fill_1
XFILLER_33_3 VGND VGND VPWR VPWR sky130_fd_sc_hd__decap_3
XTAP_TAPCELL_ROW_26_212 VGND VPWR sky130_fd_sc_hd__tapvpwrvgnd_1
XFILLER_24_250 VGND VGND VPWR VPWR sky130_fd_sc_hd__fill_2
XFILLER_15_250 VGND VGND VPWR VPWR sky130_fd_sc_hd__decap_4
XFILLER_30_253 VGND VGND VPWR VPWR sky130_fd_sc_hd__fill_1
XTAP_TAPCELL_ROW_32_237 VGND VPWR sky130_fd_sc_hd__tapvpwrvgnd_1
Xclkbuf_4_7_0_wclk clknet_0_wclk VGND VGND VPWR VPWR clknet_4_7_0_wclk sky130_fd_sc_hd__clkbuf_8
XFILLER_0_113 VGND VGND VPWR VPWR sky130_fd_sc_hd__decap_8
X_493_ bram.mem\[4\]\[3\] net6 _249_ VGND VGND VPWR VPWR _107_ sky130_fd_sc_hd__mux2_1
X_631_ clknet_4_13_0_wclk u_wrptr_handler.g_wptr_next\[2\] net12 VGND VGND VPWR VPWR
+ sync_gwptr_to_rd.d1\[2\] sky130_fd_sc_hd__dfrtp_1
X_562_ clknet_4_8_0_wclk _018_ VGND VGND VPWR VPWR bram.mem\[14\]\[2\] sky130_fd_sc_hd__dfxtp_1
XFILLER_12_253 VGND VGND VPWR VPWR sky130_fd_sc_hd__decap_4
XFILLER_5_68 VPWR VGND VPWR VGND sky130_ef_sc_hd__decap_12
Xclkbuf_4_15_0_wclk clknet_0_wclk VGND VGND VPWR VPWR clknet_4_15_0_wclk sky130_fd_sc_hd__clkbuf_8
XFILLER_38_150 VGND VGND VPWR VPWR sky130_fd_sc_hd__fill_1
XFILLER_5_249 VGND VGND VPWR VPWR sky130_fd_sc_hd__decap_8
XFILLER_5_205 VPWR VGND VPWR VGND sky130_ef_sc_hd__decap_12
X_545_ clknet_1_0__leaf_rclk _003_ VGND VGND VPWR VPWR net18 sky130_fd_sc_hd__dfxtp_1
X_476_ bram.mem\[6\]\[4\] net7 _247_ VGND VGND VPWR VPWR _092_ sky130_fd_sc_hd__mux2_1
X_614_ clknet_4_11_0_wclk _070_ VGND VGND VPWR VPWR bram.mem\[8\]\[6\] sky130_fd_sc_hd__dfxtp_1
X_330_ bram.waddr\[0\] net23 VGND VGND VPWR VPWR _199_ sky130_fd_sc_hd__nor2_1
XFILLER_25_87 VGND VGND VPWR VPWR sky130_fd_sc_hd__fill_1
XFILLER_26_120 VGND VGND VPWR VPWR sky130_fd_sc_hd__decap_4
XFILLER_26_164 VGND VGND VPWR VPWR sky130_fd_sc_hd__fill_1
XFILLER_26_197 VGND VGND VPWR VPWR sky130_fd_sc_hd__fill_2
X_261_ bram.mem\[8\]\[4\] bram.mem\[9\]\[4\] bram.mem\[10\]\[4\] bram.mem\[11\]\[4\]
+ bram.raddr\[0\] bram.raddr\[1\] VGND VGND VPWR VPWR _145_ sky130_fd_sc_hd__mux4_1
XFILLER_17_131 VPWR VGND VPWR VGND sky130_ef_sc_hd__decap_12
X_459_ bram.mem\[0\]\[5\] net8 _245_ VGND VGND VPWR VPWR _077_ sky130_fd_sc_hd__mux2_1
X_528_ clknet_4_10_0_wclk _012_ VGND VGND VPWR VPWR bram.mem\[9\]\[4\] sky130_fd_sc_hd__dfxtp_1
X_313_ bram.raddr\[0\] _189_ VGND VGND VPWR VPWR _191_ sky130_fd_sc_hd__nor2_1
XFILLER_37_215 VGND VGND VPWR VPWR sky130_fd_sc_hd__decap_8
XFILLER_37_237 VPWR VGND VPWR VGND sky130_ef_sc_hd__decap_12
XTAP_TAPCELL_ROW_15_162 VGND VPWR sky130_fd_sc_hd__tapvpwrvgnd_1
XFILLER_20_137 VGND VGND VPWR VPWR sky130_fd_sc_hd__decap_3
XFILLER_11_137 VPWR VGND VPWR VGND sky130_ef_sc_hd__decap_12
XTAP_TAPCELL_ROW_38_265 VGND VPWR sky130_fd_sc_hd__tapvpwrvgnd_1
XTAP_TAPCELL_ROW_21_187 VGND VPWR sky130_fd_sc_hd__tapvpwrvgnd_1
XFILLER_22_66 VGND VGND VPWR VPWR sky130_fd_sc_hd__fill_1
XFILLER_42_251 VGND VGND VPWR VPWR sky130_fd_sc_hd__fill_1
XFILLER_6_141 VGND VGND VPWR VPWR sky130_fd_sc_hd__decap_4
XFILLER_26_3 VGND VGND VPWR VPWR sky130_fd_sc_hd__decap_6
XFILLER_33_251 VGND VGND VPWR VPWR sky130_fd_sc_hd__decap_3
XTAP_TAPCELL_ROW_43_290 VGND VPWR sky130_fd_sc_hd__tapvpwrvgnd_1
XFILLER_16_207 VPWR VGND VPWR VGND sky130_ef_sc_hd__decap_12
XFILLER_17_11 VGND VGND VPWR VPWR sky130_fd_sc_hd__fill_1
XFILLER_17_66 VGND VGND VPWR VPWR sky130_fd_sc_hd__decap_3
XTAP_TAPCELL_ROW_26_213 VGND VPWR sky130_fd_sc_hd__tapvpwrvgnd_1
XFILLER_33_98 VGND VGND VPWR VPWR sky130_fd_sc_hd__fill_1
XTAP_TAPCELL_ROW_32_238 VGND VPWR sky130_fd_sc_hd__tapvpwrvgnd_1
XPHY_EDGE_ROW_29_Left_73 VGND VGND VPWR VPWR sky130_fd_sc_hd__decap_3
XPHY_EDGE_ROW_13_Left_57 VGND VGND VPWR VPWR sky130_fd_sc_hd__decap_3
XPHY_EDGE_ROW_3_Right_3 VGND VGND VPWR VPWR sky130_fd_sc_hd__decap_3
XFILLER_21_210 VPWR VGND VPWR VGND sky130_ef_sc_hd__decap_12
X_630_ clknet_4_7_0_wclk u_wrptr_handler.g_wptr_next\[1\] net12 VGND VGND VPWR VPWR
+ sync_gwptr_to_rd.d1\[1\] sky130_fd_sc_hd__dfrtp_1
X_492_ bram.mem\[4\]\[2\] net5 _249_ VGND VGND VPWR VPWR _106_ sky130_fd_sc_hd__mux2_1
XFILLER_12_221 VPWR VGND VPWR VGND sky130_ef_sc_hd__decap_12
X_561_ clknet_4_14_0_wclk _017_ VGND VGND VPWR VPWR bram.mem\[14\]\[1\] sky130_fd_sc_hd__dfxtp_1
XFILLER_5_217 VGND VGND VPWR VPWR sky130_fd_sc_hd__decap_6
X_613_ clknet_4_8_0_wclk _069_ VGND VGND VPWR VPWR bram.mem\[8\]\[5\] sky130_fd_sc_hd__dfxtp_1
X_544_ clknet_1_0__leaf_rclk _002_ VGND VGND VPWR VPWR net17 sky130_fd_sc_hd__dfxtp_1
X_475_ bram.mem\[6\]\[3\] net6 _247_ VGND VGND VPWR VPWR _091_ sky130_fd_sc_hd__mux2_1
XFILLER_35_143 VGND VGND VPWR VPWR sky130_fd_sc_hd__fill_1
XFILLER_2_209 VPWR VGND VPWR VGND sky130_ef_sc_hd__decap_12
XPHY_EDGE_ROW_16_Left_60 VGND VGND VPWR VPWR sky130_fd_sc_hd__decap_3
X_260_ _136_ _143_ VGND VGND VPWR VPWR _144_ sky130_fd_sc_hd__or2_1
XFILLER_41_113 VPWR VGND VPWR VGND sky130_ef_sc_hd__decap_12
XFILLER_2_15 VPWR VGND VPWR VGND sky130_ef_sc_hd__decap_12
X_527_ clknet_4_14_0_wclk _011_ VGND VGND VPWR VPWR bram.mem\[9\]\[3\] sky130_fd_sc_hd__dfxtp_1
XFILLER_17_143 VGND VGND VPWR VPWR sky130_fd_sc_hd__decap_8
X_458_ bram.mem\[0\]\[4\] net7 _245_ VGND VGND VPWR VPWR _076_ sky130_fd_sc_hd__mux2_1
X_389_ bram.mem\[14\]\[0\] net3 _236_ VGND VGND VPWR VPWR _016_ sky130_fd_sc_hd__mux2_1
XFILLER_32_179 VGND VGND VPWR VPWR sky130_fd_sc_hd__fill_2
XFILLER_11_57 VGND VGND VPWR VPWR sky130_fd_sc_hd__decap_4
XPHY_EDGE_ROW_1_Left_45 VGND VGND VPWR VPWR sky130_fd_sc_hd__decap_3
X_312_ bram.raddr\[0\] _189_ VGND VGND VPWR VPWR _190_ sky130_fd_sc_hd__and2_1
XFILLER_37_249 VGND VGND VPWR VPWR sky130_fd_sc_hd__decap_8
XTAP_TAPCELL_ROW_15_163 VGND VPWR sky130_fd_sc_hd__tapvpwrvgnd_1
XPHY_EDGE_ROW_43_Left_87 VGND VGND VPWR VPWR sky130_fd_sc_hd__decap_3
XTAP_TAPCELL_ROW_38_266 VGND VPWR sky130_fd_sc_hd__tapvpwrvgnd_1
XFILLER_11_149 VGND VGND VPWR VPWR sky130_fd_sc_hd__decap_8
XTAP_TAPCELL_ROW_21_188 VGND VPWR sky130_fd_sc_hd__tapvpwrvgnd_1
XTAP_TAPCELL_ROW_6_120 VGND VPWR sky130_fd_sc_hd__tapvpwrvgnd_1
XFILLER_6_197 VPWR VGND VPWR VGND sky130_ef_sc_hd__decap_12
XFILLER_19_3 VPWR VGND VPWR VGND sky130_ef_sc_hd__decap_12
XTAP_TAPCELL_ROW_43_291 VGND VPWR sky130_fd_sc_hd__tapvpwrvgnd_1
XFILLER_16_219 VPWR VGND VPWR VGND sky130_ef_sc_hd__decap_12
XFILLER_33_22 VGND VGND VPWR VPWR sky130_fd_sc_hd__fill_2
XFILLER_33_33 VGND VGND VPWR VPWR sky130_fd_sc_hd__fill_2
XFILLER_33_44 VPWR VGND VPWR VGND sky130_ef_sc_hd__decap_12
XFILLER_33_66 VPWR VGND VPWR VGND sky130_ef_sc_hd__decap_12
XFILLER_3_156 VGND VGND VPWR VPWR sky130_fd_sc_hd__decap_3
XTAP_TAPCELL_ROW_32_239 VGND VPWR sky130_fd_sc_hd__tapvpwrvgnd_1
XTAP_TAPCELL_ROW_40_272 VGND VPWR sky130_fd_sc_hd__tapvpwrvgnd_1
XFILLER_21_222 VGND VGND VPWR VPWR sky130_fd_sc_hd__fill_2
X_560_ clknet_4_12_0_wclk _016_ VGND VGND VPWR VPWR bram.mem\[14\]\[0\] sky130_fd_sc_hd__dfxtp_1
X_491_ bram.mem\[4\]\[1\] net4 _249_ VGND VGND VPWR VPWR _105_ sky130_fd_sc_hd__mux2_1
XFILLER_12_233 VPWR VGND VPWR VGND sky130_ef_sc_hd__decap_12
XFILLER_5_15 VGND VGND VPWR VPWR sky130_fd_sc_hd__decap_6
XPHY_EDGE_ROW_30_Left_74 VGND VGND VPWR VPWR sky130_fd_sc_hd__decap_3
XPHY_EDGE_ROW_13_Right_13 VGND VGND VPWR VPWR sky130_fd_sc_hd__decap_3
X_689_ clknet_4_8_0_wclk _127_ VGND VGND VPWR VPWR bram.mem\[15\]\[7\] sky130_fd_sc_hd__dfxtp_1
XPHY_EDGE_ROW_22_Right_22 VGND VGND VPWR VPWR sky130_fd_sc_hd__decap_3
XPHY_EDGE_ROW_31_Right_31 VGND VGND VPWR VPWR sky130_fd_sc_hd__decap_3
XPHY_EDGE_ROW_40_Right_40 VGND VGND VPWR VPWR sky130_fd_sc_hd__decap_3
XFILLER_29_185 VPWR VGND VPWR VGND sky130_ef_sc_hd__decap_12
X_612_ clknet_4_10_0_wclk _068_ VGND VGND VPWR VPWR bram.mem\[8\]\[4\] sky130_fd_sc_hd__dfxtp_1
X_543_ clknet_1_0__leaf_rclk _001_ VGND VGND VPWR VPWR net16 sky130_fd_sc_hd__dfxtp_1
X_474_ bram.mem\[6\]\[2\] net5 _247_ VGND VGND VPWR VPWR _090_ sky130_fd_sc_hd__mux2_1
XFILLER_4_251 VGND VGND VPWR VPWR sky130_fd_sc_hd__fill_1
XFILLER_41_125 VGND VGND VPWR VPWR sky130_fd_sc_hd__fill_2
XFILLER_41_55 VGND VGND VPWR VPWR sky130_fd_sc_hd__fill_1
XFILLER_1_221 VGND VGND VPWR VPWR sky130_fd_sc_hd__decap_3
XFILLER_2_27 VGND VGND VPWR VPWR sky130_fd_sc_hd__fill_1
X_526_ clknet_4_8_0_wclk _010_ VGND VGND VPWR VPWR bram.mem\[9\]\[2\] sky130_fd_sc_hd__dfxtp_1
X_457_ bram.mem\[0\]\[3\] net6 _245_ VGND VGND VPWR VPWR _075_ sky130_fd_sc_hd__mux2_1
X_388_ bram.waddr\[0\] bram.waddr\[1\] net23 _203_ VGND VGND VPWR VPWR _236_ sky130_fd_sc_hd__and4b_4
XFILLER_11_25 VGND VGND VPWR VPWR sky130_fd_sc_hd__decap_4
X_311_ _186_ _187_ _188_ net1 VGND VGND VPWR VPWR _189_ sky130_fd_sc_hd__o31a_1
XFILLER_20_117 VGND VGND VPWR VPWR sky130_fd_sc_hd__decap_3
X_509_ net5 bram.mem\[15\]\[2\] _204_ VGND VGND VPWR VPWR _122_ sky130_fd_sc_hd__mux2_1
XFILLER_43_209 VPWR VGND VPWR VGND sky130_ef_sc_hd__decap_12
XTAP_TAPCELL_ROW_38_267 VGND VPWR sky130_fd_sc_hd__tapvpwrvgnd_1
XFILLER_11_106 VGND VGND VPWR VPWR sky130_fd_sc_hd__decap_6
XFILLER_22_24 VGND VGND VPWR VPWR sky130_fd_sc_hd__decap_4
XTAP_TAPCELL_ROW_21_189 VGND VPWR sky130_fd_sc_hd__tapvpwrvgnd_1
XTAP_TAPCELL_ROW_6_121 VGND VPWR sky130_fd_sc_hd__tapvpwrvgnd_1
XTAP_TAPCELL_ROW_29_223 VGND VPWR sky130_fd_sc_hd__tapvpwrvgnd_1
XFILLER_42_253 VGND VGND VPWR VPWR sky130_fd_sc_hd__decap_4
XFILLER_8_15 VPWR VGND VPWR VGND sky130_ef_sc_hd__decap_12
XFILLER_10_150 VGND VGND VPWR VPWR sky130_fd_sc_hd__fill_2
XTAP_TAPCELL_ROW_43_292 VGND VPWR sky130_fd_sc_hd__tapvpwrvgnd_1
XFILLER_24_253 VGND VGND VPWR VPWR sky130_fd_sc_hd__fill_1
XFILLER_33_78 VPWR VGND VPWR VGND sky130_ef_sc_hd__decap_12
XFILLER_3_113 VGND VGND VPWR VPWR sky130_fd_sc_hd__decap_4
XTAP_TAPCELL_ROW_40_273 VGND VPWR sky130_fd_sc_hd__tapvpwrvgnd_1
XFILLER_31_3 VGND VGND VPWR VPWR sky130_fd_sc_hd__decap_3
XFILLER_21_256 VGND VGND VPWR VPWR sky130_fd_sc_hd__fill_1
XFILLER_28_45 VGND VGND VPWR VPWR sky130_fd_sc_hd__decap_4
X_490_ bram.mem\[4\]\[0\] net3 _249_ VGND VGND VPWR VPWR _104_ sky130_fd_sc_hd__mux2_1
XFILLER_12_245 VGND VGND VPWR VPWR sky130_fd_sc_hd__decap_6
XFILLER_5_38 VGND VGND VPWR VPWR sky130_fd_sc_hd__decap_4
X_688_ clknet_4_10_0_wclk _126_ VGND VGND VPWR VPWR bram.mem\[15\]\[6\] sky130_fd_sc_hd__dfxtp_1
XFILLER_30_24 VGND VGND VPWR VPWR sky130_fd_sc_hd__decap_4
XFILLER_39_11 VGND VGND VPWR VPWR sky130_fd_sc_hd__fill_2
XFILLER_39_22 VPWR VGND VPWR VGND sky130_ef_sc_hd__decap_12
X_473_ bram.mem\[6\]\[1\] net4 _247_ VGND VGND VPWR VPWR _089_ sky130_fd_sc_hd__mux2_1
X_542_ clknet_1_1__leaf_rclk _000_ VGND VGND VPWR VPWR net15 sky130_fd_sc_hd__dfxtp_1
XFILLER_29_197 VPWR VGND VPWR VGND sky130_ef_sc_hd__decap_12
X_611_ clknet_4_14_0_wclk _067_ VGND VGND VPWR VPWR bram.mem\[8\]\[3\] sky130_fd_sc_hd__dfxtp_1
XFILLER_35_167 VGND VGND VPWR VPWR sky130_fd_sc_hd__fill_1
XFILLER_26_134 VGND VGND VPWR VPWR sky130_fd_sc_hd__decap_6
XFILLER_25_57 VGND VGND VPWR VPWR sky130_fd_sc_hd__decap_4
XFILLER_9_3 VPWR VGND VPWR VGND sky130_ef_sc_hd__decap_12
X_525_ clknet_4_15_0_wclk _009_ VGND VGND VPWR VPWR bram.mem\[9\]\[1\] sky130_fd_sc_hd__dfxtp_1
X_456_ bram.mem\[0\]\[2\] net5 _245_ VGND VGND VPWR VPWR _074_ sky130_fd_sc_hd__mux2_1
XFILLER_32_126 VGND VGND VPWR VPWR sky130_fd_sc_hd__fill_1
XFILLER_32_159 VPWR VGND VPWR VGND sky130_ef_sc_hd__decap_12
X_387_ net10 bram.mem\[9\]\[7\] _235_ VGND VGND VPWR VPWR _015_ sky130_fd_sc_hd__mux2_1
XFILLER_40_192 VGND VGND VPWR VPWR sky130_fd_sc_hd__fill_1
XTAP_TAPCELL_ROW_18_173 VGND VPWR sky130_fd_sc_hd__tapvpwrvgnd_1
XFILLER_31_181 VPWR VGND VPWR VGND sky130_ef_sc_hd__decap_12
X_310_ _186_ _187_ _188_ VGND VGND VPWR VPWR net13 sky130_fd_sc_hd__nor3_1
X_439_ net7 bram.mem\[7\]\[4\] _242_ VGND VGND VPWR VPWR _060_ sky130_fd_sc_hd__mux2_1
XFILLER_20_129 VGND VGND VPWR VPWR sky130_fd_sc_hd__decap_8
X_508_ net4 bram.mem\[15\]\[1\] _204_ VGND VGND VPWR VPWR _121_ sky130_fd_sc_hd__mux2_1
XFILLER_22_47 VGND VGND VPWR VPWR sky130_fd_sc_hd__decap_3
XTAP_TAPCELL_ROW_6_122 VGND VPWR sky130_fd_sc_hd__tapvpwrvgnd_1
XTAP_TAPCELL_ROW_29_224 VGND VPWR sky130_fd_sc_hd__tapvpwrvgnd_1
XFILLER_42_221 VPWR VGND VPWR VGND sky130_ef_sc_hd__decap_12
XFILLER_8_27 VGND VGND VPWR VPWR sky130_fd_sc_hd__fill_1
XFILLER_6_122 VGND VGND VPWR VPWR sky130_fd_sc_hd__decap_4
XTAP_TAPCELL_ROW_12_146 VGND VPWR sky130_fd_sc_hd__tapvpwrvgnd_1
XFILLER_18_240 VGND VGND VPWR VPWR sky130_fd_sc_hd__fill_2
XTAP_TAPCELL_ROW_43_293 VGND VPWR sky130_fd_sc_hd__tapvpwrvgnd_1
Xclkbuf_4_2_0_wclk clknet_0_wclk VGND VGND VPWR VPWR clknet_4_2_0_wclk sky130_fd_sc_hd__clkbuf_8
XTAP_TAPCELL_ROW_40_274 VGND VPWR sky130_fd_sc_hd__tapvpwrvgnd_1
XFILLER_24_3 VGND VGND VPWR VPWR sky130_fd_sc_hd__decap_3
XFILLER_0_94 VGND VGND VPWR VPWR sky130_fd_sc_hd__decap_4
XFILLER_0_139 VGND VGND VPWR VPWR sky130_fd_sc_hd__fill_1
XFILLER_28_79 VGND VGND VPWR VPWR sky130_fd_sc_hd__decap_4
Xclkbuf_4_10_0_wclk clknet_0_wclk VGND VGND VPWR VPWR clknet_4_10_0_wclk sky130_fd_sc_hd__clkbuf_8
X_687_ clknet_4_9_0_wclk _125_ VGND VGND VPWR VPWR bram.mem\[15\]\[5\] sky130_fd_sc_hd__dfxtp_1
XPHY_EDGE_ROW_7_Right_7 VGND VGND VPWR VPWR sky130_fd_sc_hd__decap_3
XFILLER_14_15 VPWR VGND VPWR VGND sky130_ef_sc_hd__decap_12
XFILLER_14_37 VGND VGND VPWR VPWR sky130_fd_sc_hd__fill_1
X_610_ clknet_4_8_0_wclk _066_ VGND VGND VPWR VPWR bram.mem\[8\]\[2\] sky130_fd_sc_hd__dfxtp_1
XFILLER_39_34 VPWR VGND VPWR VGND sky130_ef_sc_hd__decap_12
X_472_ bram.mem\[6\]\[0\] net3 _247_ VGND VGND VPWR VPWR _088_ sky130_fd_sc_hd__mux2_1
X_541_ clknet_1_1__leaf_rclk sync_gwptr_to_rd.d1\[4\] net2 VGND VGND VPWR VPWR sync_gwptr_to_rd.q1\[4\]
+ sky130_fd_sc_hd__dfrtp_1
XFILLER_4_253 VGND VGND VPWR VPWR sky130_fd_sc_hd__decap_4
XFILLER_20_80 VGND VGND VPWR VPWR sky130_fd_sc_hd__decap_4
XFILLER_26_113 VGND VGND VPWR VPWR sky130_fd_sc_hd__fill_1
XFILLER_26_124 VGND VGND VPWR VPWR sky130_fd_sc_hd__fill_1
XFILLER_41_57 VGND VGND VPWR VPWR sky130_fd_sc_hd__fill_2
Xclkbuf_1_0__f_rclk clknet_0_rclk VGND VGND VPWR VPWR clknet_1_0__leaf_rclk sky130_fd_sc_hd__clkbuf_16
XFILLER_2_29 VGND VGND VPWR VPWR sky130_fd_sc_hd__decap_6
XFILLER_17_113 VGND VGND VPWR VPWR sky130_fd_sc_hd__fill_2
X_386_ net9 bram.mem\[9\]\[6\] _235_ VGND VGND VPWR VPWR _014_ sky130_fd_sc_hd__mux2_1
X_455_ bram.mem\[0\]\[1\] net4 _245_ VGND VGND VPWR VPWR _073_ sky130_fd_sc_hd__mux2_1
X_524_ clknet_4_6_0_wclk _008_ VGND VGND VPWR VPWR bram.mem\[9\]\[0\] sky130_fd_sc_hd__dfxtp_1
XFILLER_32_149 VGND VGND VPWR VPWR sky130_fd_sc_hd__fill_1
XTAP_TAPCELL_ROW_18_174 VGND VPWR sky130_fd_sc_hd__tapvpwrvgnd_1
XFILLER_31_160 VGND VGND VPWR VPWR sky130_fd_sc_hd__decap_8
XFILLER_31_193 VGND VGND VPWR VPWR sky130_fd_sc_hd__fill_2
XFILLER_9_164 VGND VGND VPWR VPWR sky130_fd_sc_hd__decap_4
XFILLER_13_160 VGND VGND VPWR VPWR sky130_fd_sc_hd__decap_8
X_438_ net6 bram.mem\[7\]\[3\] _242_ VGND VGND VPWR VPWR _059_ sky130_fd_sc_hd__mux2_1
X_369_ _221_ _223_ _226_ _137_ VGND VGND VPWR VPWR _002_ sky130_fd_sc_hd__a22o_1
X_507_ net3 bram.mem\[15\]\[0\] _204_ VGND VGND VPWR VPWR _120_ sky130_fd_sc_hd__mux2_1
XPHY_EDGE_ROW_5_Left_49 VGND VGND VPWR VPWR sky130_fd_sc_hd__decap_3
XTAP_TAPCELL_ROW_6_123 VGND VPWR sky130_fd_sc_hd__tapvpwrvgnd_1
XTAP_TAPCELL_ROW_29_225 VGND VPWR sky130_fd_sc_hd__tapvpwrvgnd_1
XFILLER_42_233 VPWR VGND VPWR VGND sky130_ef_sc_hd__decap_12
XTAP_TAPCELL_ROW_12_147 VGND VPWR sky130_fd_sc_hd__tapvpwrvgnd_1
XFILLER_6_145 VGND VGND VPWR VPWR sky130_fd_sc_hd__fill_1
XFILLER_40_9 VPWR VGND VPWR VGND sky130_ef_sc_hd__decap_12
XFILLER_33_200 VGND VGND VPWR VPWR sky130_fd_sc_hd__decap_4
XTAP_TAPCELL_ROW_43_294 VGND VPWR sky130_fd_sc_hd__tapvpwrvgnd_1
XFILLER_3_148 VGND VGND VPWR VPWR sky130_fd_sc_hd__decap_8
XTAP_TAPCELL_ROW_40_275 VGND VPWR sky130_fd_sc_hd__tapvpwrvgnd_1
XFILLER_17_3 VGND VGND VPWR VPWR sky130_fd_sc_hd__decap_8
XFILLER_0_107 VGND VGND VPWR VPWR sky130_fd_sc_hd__decap_4
XPHY_EDGE_ROW_8_Left_52 VGND VGND VPWR VPWR sky130_fd_sc_hd__decap_3
X_686_ clknet_4_9_0_wclk _124_ VGND VGND VPWR VPWR bram.mem\[15\]\[4\] sky130_fd_sc_hd__dfxtp_1
XFILLER_38_111 VGND VGND VPWR VPWR sky130_fd_sc_hd__decap_6
XFILLER_38_122 VPWR VGND VPWR VGND sky130_ef_sc_hd__decap_12
XFILLER_14_27 VGND VGND VPWR VPWR sky130_fd_sc_hd__fill_1
XFILLER_29_111 VGND VGND VPWR VPWR sky130_fd_sc_hd__fill_1
X_540_ clknet_1_1__leaf_rclk sync_gwptr_to_rd.d1\[3\] net2 VGND VGND VPWR VPWR sync_gwptr_to_rd.q1\[3\]
+ sky130_fd_sc_hd__dfrtp_1
XPHY_EDGE_ROW_34_Left_78 VGND VGND VPWR VPWR sky130_fd_sc_hd__decap_3
XFILLER_39_46 VGND VGND VPWR VPWR sky130_fd_sc_hd__fill_1
XFILLER_39_57 VGND VGND VPWR VPWR sky130_fd_sc_hd__decap_6
XFILLER_39_79 VGND VGND VPWR VPWR sky130_fd_sc_hd__fill_1
X_471_ bram.waddr\[0\] bram.waddr\[1\] net23 _241_ VGND VGND VPWR VPWR _247_ sky130_fd_sc_hd__and4b_4
XFILLER_4_221 VPWR VGND VPWR VGND sky130_ef_sc_hd__decap_12
X_669_ clknet_4_4_0_wclk _107_ VGND VGND VPWR VPWR bram.mem\[4\]\[3\] sky130_fd_sc_hd__dfxtp_1
XFILLER_43_191 VGND VGND VPWR VPWR sky130_fd_sc_hd__decap_4
XFILLER_25_15 VGND VGND VPWR VPWR sky130_fd_sc_hd__fill_2
XFILLER_25_26 VGND VGND VPWR VPWR sky130_fd_sc_hd__decap_4
X_523_ bram.mem\[2\]\[7\] net10 _251_ VGND VGND VPWR VPWR _135_ sky130_fd_sc_hd__mux2_1
X_454_ bram.mem\[0\]\[0\] net3 _245_ VGND VGND VPWR VPWR _072_ sky130_fd_sc_hd__mux2_1
X_385_ net8 bram.mem\[9\]\[5\] _235_ VGND VGND VPWR VPWR _013_ sky130_fd_sc_hd__mux2_1
XFILLER_32_139 VGND VGND VPWR VPWR sky130_fd_sc_hd__fill_1
XTAP_TAPCELL_ROW_18_175 VGND VPWR sky130_fd_sc_hd__tapvpwrvgnd_1
XFILLER_23_139 VGND VGND VPWR VPWR sky130_fd_sc_hd__fill_1
XFILLER_36_25 VGND VGND VPWR VPWR sky130_fd_sc_hd__decap_3
XFILLER_22_150 VGND VGND VPWR VPWR sky130_fd_sc_hd__decap_4
X_506_ net10 bram.mem\[1\]\[7\] _250_ VGND VGND VPWR VPWR _119_ sky130_fd_sc_hd__mux2_1
XFILLER_26_91 VGND VGND VPWR VPWR sky130_fd_sc_hd__decap_8
XPHY_EDGE_ROW_37_Left_81 VGND VGND VPWR VPWR sky130_fd_sc_hd__decap_3
XFILLER_9_187 VPWR VGND VPWR VGND sky130_ef_sc_hd__decap_12
X_368_ _224_ _225_ bram.raddr\[2\] VGND VGND VPWR VPWR _226_ sky130_fd_sc_hd__mux2_1
X_437_ net5 bram.mem\[7\]\[2\] _242_ VGND VGND VPWR VPWR _058_ sky130_fd_sc_hd__mux2_1
XFILLER_20_109 VGND VGND VPWR VPWR sky130_fd_sc_hd__decap_8
XPHY_EDGE_ROW_21_Left_65 VGND VGND VPWR VPWR sky130_fd_sc_hd__decap_3
X_299_ sync_gwptr_to_rd.d1\[4\] r_ptr_gray_sync\[4\] VGND VGND VPWR VPWR _179_ sky130_fd_sc_hd__xnor2_1
XFILLER_36_253 VGND VGND VPWR VPWR sky130_fd_sc_hd__decap_4
XFILLER_42_245 VGND VGND VPWR VPWR sky130_fd_sc_hd__decap_6
XTAP_TAPCELL_ROW_29_226 VGND VPWR sky130_fd_sc_hd__tapvpwrvgnd_1
XPHY_EDGE_ROW_29_Right_29 VGND VGND VPWR VPWR sky130_fd_sc_hd__decap_3
XFILLER_10_120 VGND VGND VPWR VPWR sky130_fd_sc_hd__decap_3
XFILLER_8_29 VGND VGND VPWR VPWR sky130_fd_sc_hd__decap_8
XTAP_TAPCELL_ROW_12_148 VGND VPWR sky130_fd_sc_hd__tapvpwrvgnd_1
XPHY_EDGE_ROW_38_Right_38 VGND VGND VPWR VPWR sky130_fd_sc_hd__decap_3
XFILLER_10_197 VPWR VGND VPWR VGND sky130_ef_sc_hd__decap_12
XFILLER_18_253 VGND VGND VPWR VPWR sky130_fd_sc_hd__decap_4
XTAP_TAPCELL_ROW_40_276 VGND VPWR sky130_fd_sc_hd__tapvpwrvgnd_1
XFILLER_2_193 VGND VGND VPWR VPWR sky130_fd_sc_hd__decap_3
XFILLER_9_83 VGND VGND VPWR VPWR sky130_fd_sc_hd__fill_1
XTAP_TAPCELL_ROW_31_232 VGND VPWR sky130_fd_sc_hd__tapvpwrvgnd_1
XFILLER_28_15 VGND VGND VPWR VPWR sky130_fd_sc_hd__decap_3
X_685_ clknet_4_11_0_wclk _123_ VGND VGND VPWR VPWR bram.mem\[15\]\[3\] sky130_fd_sc_hd__dfxtp_1
XFILLER_34_91 VGND VGND VPWR VPWR sky130_fd_sc_hd__fill_2
XFILLER_38_134 VGND VGND VPWR VPWR sky130_fd_sc_hd__decap_6
X_470_ net10 bram.mem\[5\]\[7\] _246_ VGND VGND VPWR VPWR _087_ sky130_fd_sc_hd__mux2_1
XFILLER_4_233 VPWR VGND VPWR VGND sky130_ef_sc_hd__decap_12
X_668_ clknet_4_0_0_wclk _106_ VGND VGND VPWR VPWR bram.mem\[4\]\[2\] sky130_fd_sc_hd__dfxtp_1
X_599_ clknet_4_10_0_wclk _055_ VGND VGND VPWR VPWR bram.mem\[10\]\[7\] sky130_fd_sc_hd__dfxtp_1
XFILLER_43_181 VGND VGND VPWR VPWR sky130_fd_sc_hd__decap_4
XFILLER_41_15 VPWR VGND VPWR VGND sky130_ef_sc_hd__decap_12
XFILLER_1_225 VPWR VGND VPWR VGND sky130_ef_sc_hd__decap_12
X_522_ bram.mem\[2\]\[6\] net9 _251_ VGND VGND VPWR VPWR _134_ sky130_fd_sc_hd__mux2_1
X_453_ bram.waddr\[0\] bram.waddr\[1\] net23 _244_ VGND VGND VPWR VPWR _245_ sky130_fd_sc_hd__and4bb_4
XFILLER_32_118 VGND VGND VPWR VPWR sky130_fd_sc_hd__decap_8
Xclkbuf_4_8_0_wclk clknet_0_wclk VGND VGND VPWR VPWR clknet_4_8_0_wclk sky130_fd_sc_hd__clkbuf_8
X_384_ net7 bram.mem\[9\]\[4\] _235_ VGND VGND VPWR VPWR _012_ sky130_fd_sc_hd__mux2_1
XFILLER_16_192 VGND VGND VPWR VPWR sky130_fd_sc_hd__decap_4
XTAP_TAPCELL_ROW_18_176 VGND VPWR sky130_fd_sc_hd__tapvpwrvgnd_1
XFILLER_36_48 VGND VGND VPWR VPWR sky130_fd_sc_hd__fill_2
XTAP_TAPCELL_ROW_9_133 VGND VPWR sky130_fd_sc_hd__tapvpwrvgnd_1
XFILLER_7_3 VPWR VGND VPWR VGND sky130_ef_sc_hd__decap_12
XFILLER_9_100 VGND VGND VPWR VPWR sky130_fd_sc_hd__decap_3
X_436_ net4 bram.mem\[7\]\[1\] _242_ VGND VGND VPWR VPWR _057_ sky130_fd_sc_hd__mux2_1
X_505_ net9 bram.mem\[1\]\[6\] _250_ VGND VGND VPWR VPWR _118_ sky130_fd_sc_hd__mux2_1
XFILLER_9_199 VPWR VGND VPWR VGND sky130_ef_sc_hd__decap_12
XFILLER_9_133 VGND VGND VPWR VPWR sky130_fd_sc_hd__decap_6
X_367_ bram.mem\[4\]\[2\] bram.mem\[5\]\[2\] bram.mem\[6\]\[2\] bram.mem\[7\]\[2\]
+ bram.raddr\[0\] bram.raddr\[1\] VGND VGND VPWR VPWR _225_ sky130_fd_sc_hd__mux4_1
X_298_ bram.waddr\[2\] _172_ VGND VGND VPWR VPWR _178_ sky130_fd_sc_hd__nand2_1
XTAP_TAPCELL_ROW_37_260 VGND VPWR sky130_fd_sc_hd__tapvpwrvgnd_1
XFILLER_10_132 VGND VGND VPWR VPWR sky130_fd_sc_hd__decap_8
XFILLER_6_136 VGND VGND VPWR VPWR sky130_fd_sc_hd__decap_4
XTAP_TAPCELL_ROW_12_149 VGND VPWR sky130_fd_sc_hd__tapvpwrvgnd_1
XTAP_TAPCELL_ROW_20_182 VGND VPWR sky130_fd_sc_hd__tapvpwrvgnd_1
X_419_ net6 bram.mem\[11\]\[3\] _239_ VGND VGND VPWR VPWR _043_ sky130_fd_sc_hd__mux2_1
XTAP_TAPCELL_ROW_3_106 VGND VPWR sky130_fd_sc_hd__tapvpwrvgnd_1
XFILLER_17_28 VGND VGND VPWR VPWR sky130_fd_sc_hd__decap_6
XFILLER_24_202 VGND VGND VPWR VPWR sky130_fd_sc_hd__decap_8
XFILLER_3_117 VGND VGND VPWR VPWR sky130_fd_sc_hd__fill_1
XFILLER_2_150 VGND VGND VPWR VPWR sky130_fd_sc_hd__fill_2
XTAP_TAPCELL_ROW_31_233 VGND VPWR sky130_fd_sc_hd__tapvpwrvgnd_1
XFILLER_28_27 VGND VGND VPWR VPWR sky130_fd_sc_hd__fill_1
XFILLER_8_209 VPWR VGND VPWR VGND sky130_ef_sc_hd__decap_12
X_684_ clknet_4_8_0_wclk _122_ VGND VGND VPWR VPWR bram.mem\[15\]\[2\] sky130_fd_sc_hd__dfxtp_1
XFILLER_22_3 VGND VGND VPWR VPWR sky130_fd_sc_hd__decap_4
XFILLER_14_29 VGND VGND VPWR VPWR sky130_fd_sc_hd__decap_8
XFILLER_4_245 VGND VGND VPWR VPWR sky130_fd_sc_hd__decap_6
XFILLER_43_160 VGND VGND VPWR VPWR sky130_fd_sc_hd__decap_4
X_667_ clknet_4_5_0_wclk _105_ VGND VGND VPWR VPWR bram.mem\[4\]\[1\] sky130_fd_sc_hd__dfxtp_1
X_598_ clknet_4_10_0_wclk _054_ VGND VGND VPWR VPWR bram.mem\[10\]\[6\] sky130_fd_sc_hd__dfxtp_1
XFILLER_6_85 VGND VGND VPWR VPWR sky130_fd_sc_hd__fill_2
XFILLER_41_27 VPWR VGND VPWR VGND sky130_ef_sc_hd__decap_12
XFILLER_1_237 VPWR VGND VPWR VGND sky130_ef_sc_hd__decap_12
X_521_ bram.mem\[2\]\[5\] net8 _251_ VGND VGND VPWR VPWR _133_ sky130_fd_sc_hd__mux2_1
X_452_ bram.waddr\[3\] bram.waddr\[2\] VGND VGND VPWR VPWR _244_ sky130_fd_sc_hd__nor2_2
XFILLER_25_182 VGND VGND VPWR VPWR sky130_fd_sc_hd__fill_1
X_383_ net6 bram.mem\[9\]\[3\] _235_ VGND VGND VPWR VPWR _011_ sky130_fd_sc_hd__mux2_1
XFILLER_40_141 VPWR VGND VPWR VGND sky130_ef_sc_hd__decap_12
XFILLER_40_174 VPWR VGND VPWR VGND sky130_ef_sc_hd__decap_12
XFILLER_16_160 VGND VGND VPWR VPWR sky130_fd_sc_hd__decap_8
XTAP_TAPCELL_ROW_18_177 VGND VPWR sky130_fd_sc_hd__tapvpwrvgnd_1
XFILLER_22_174 VGND VGND VPWR VPWR sky130_fd_sc_hd__fill_2
XTAP_TAPCELL_ROW_9_134 VGND VPWR sky130_fd_sc_hd__tapvpwrvgnd_1
X_435_ net3 bram.mem\[7\]\[0\] _242_ VGND VGND VPWR VPWR _056_ sky130_fd_sc_hd__mux2_1
X_366_ bram.mem\[0\]\[2\] bram.mem\[1\]\[2\] bram.mem\[2\]\[2\] bram.mem\[3\]\[2\]
+ bram.raddr\[0\] bram.raddr\[1\] VGND VGND VPWR VPWR _224_ sky130_fd_sc_hd__mux4_1
X_504_ net8 bram.mem\[1\]\[5\] _250_ VGND VGND VPWR VPWR _117_ sky130_fd_sc_hd__mux2_1
X_297_ _175_ _176_ _173_ VGND VGND VPWR VPWR _177_ sky130_fd_sc_hd__mux2_1
XFILLER_36_200 VGND VGND VPWR VPWR sky130_fd_sc_hd__decap_6
XFILLER_22_29 VGND VGND VPWR VPWR sky130_fd_sc_hd__fill_2
XTAP_TAPCELL_ROW_37_261 VGND VPWR sky130_fd_sc_hd__tapvpwrvgnd_1
XFILLER_6_126 VGND VGND VPWR VPWR sky130_fd_sc_hd__fill_1
XFILLER_12_51 VGND VGND VPWR VPWR sky130_fd_sc_hd__fill_1
XTAP_TAPCELL_ROW_20_183 VGND VPWR sky130_fd_sc_hd__tapvpwrvgnd_1
XFILLER_33_225 VGND VGND VPWR VPWR sky130_fd_sc_hd__decap_4
XTAP_TAPCELL_ROW_43_286 VGND VPWR sky130_fd_sc_hd__tapvpwrvgnd_1
X_349_ _136_ _208_ bram.raddr\[3\] VGND VGND VPWR VPWR _209_ sky130_fd_sc_hd__o21a_1
X_418_ net5 bram.mem\[11\]\[2\] _239_ VGND VGND VPWR VPWR _042_ sky130_fd_sc_hd__mux2_1
XFILLER_5_181 VPWR VGND VPWR VGND sky130_ef_sc_hd__decap_12
XTAP_TAPCELL_ROW_3_107 VGND VPWR sky130_fd_sc_hd__tapvpwrvgnd_1
XTAP_TAPCELL_ROW_26_209 VGND VPWR sky130_fd_sc_hd__tapvpwrvgnd_1
XFILLER_15_225 VGND VGND VPWR VPWR sky130_fd_sc_hd__decap_4
XFILLER_30_217 VGND VGND VPWR VPWR sky130_fd_sc_hd__decap_4
XFILLER_30_228 VGND VGND VPWR VPWR sky130_fd_sc_hd__decap_4
XFILLER_0_76 VGND VGND VPWR VPWR sky130_fd_sc_hd__fill_2
XTAP_TAPCELL_ROW_31_234 VGND VPWR sky130_fd_sc_hd__tapvpwrvgnd_1
XFILLER_18_50 VGND VGND VPWR VPWR sky130_fd_sc_hd__decap_4
X_683_ clknet_4_15_0_wclk _121_ VGND VGND VPWR VPWR bram.mem\[15\]\[1\] sky130_fd_sc_hd__dfxtp_1
XFILLER_7_221 VGND VGND VPWR VPWR sky130_fd_sc_hd__decap_3
XFILLER_15_3 VPWR VGND VPWR VGND sky130_ef_sc_hd__decap_12
XFILLER_30_29 VPWR VGND VPWR VGND sky130_ef_sc_hd__decap_12
X_666_ clknet_4_5_0_wclk _104_ VGND VGND VPWR VPWR bram.mem\[4\]\[0\] sky130_fd_sc_hd__dfxtp_1
X_597_ clknet_4_8_0_wclk _053_ VGND VGND VPWR VPWR bram.mem\[10\]\[5\] sky130_fd_sc_hd__dfxtp_1
XFILLER_34_194 VGND VGND VPWR VPWR sky130_fd_sc_hd__fill_2
XFILLER_41_39 VPWR VGND VPWR VGND sky130_ef_sc_hd__decap_12
XFILLER_1_249 VGND VGND VPWR VPWR sky130_fd_sc_hd__decap_8
X_520_ bram.mem\[2\]\[4\] net7 _251_ VGND VGND VPWR VPWR _132_ sky130_fd_sc_hd__mux2_1
X_382_ net5 bram.mem\[9\]\[2\] _235_ VGND VGND VPWR VPWR _010_ sky130_fd_sc_hd__mux2_1
X_451_ bram.mem\[8\]\[7\] net10 _243_ VGND VGND VPWR VPWR _071_ sky130_fd_sc_hd__mux2_1
XFILLER_40_186 VGND VGND VPWR VPWR sky130_fd_sc_hd__decap_6
XFILLER_40_197 VGND VGND VPWR VPWR sky130_fd_sc_hd__decap_4
X_649_ clknet_4_5_0_wclk _096_ VGND VGND VPWR VPWR bram.mem\[3\]\[0\] sky130_fd_sc_hd__dfxtp_1
XFILLER_22_197 VGND VGND VPWR VPWR sky130_fd_sc_hd__decap_3
XTAP_TAPCELL_ROW_9_135 VGND VPWR sky130_fd_sc_hd__tapvpwrvgnd_1
X_503_ net7 bram.mem\[1\]\[4\] _250_ VGND VGND VPWR VPWR _116_ sky130_fd_sc_hd__mux2_1
XFILLER_9_113 VGND VGND VPWR VPWR sky130_fd_sc_hd__decap_4
X_296_ bram.waddr\[1\] _174_ VGND VGND VPWR VPWR _176_ sky130_fd_sc_hd__and2_1
X_434_ bram.waddr\[0\] bram.waddr\[1\] net23 _241_ VGND VGND VPWR VPWR _242_ sky130_fd_sc_hd__nand4_4
XFILLER_26_83 VGND VGND VPWR VPWR sky130_fd_sc_hd__fill_1
X_365_ _136_ _222_ bram.raddr\[3\] VGND VGND VPWR VPWR _223_ sky130_fd_sc_hd__o21a_1
XFILLER_42_82 VGND VGND VPWR VPWR sky130_fd_sc_hd__fill_2
XFILLER_27_223 VGND VGND VPWR VPWR sky130_fd_sc_hd__fill_1
XFILLER_27_256 VGND VGND VPWR VPWR sky130_fd_sc_hd__fill_1
XFILLER_10_112 VGND VGND VPWR VPWR sky130_fd_sc_hd__decap_8
XTAP_TAPCELL_ROW_37_262 VGND VPWR sky130_fd_sc_hd__tapvpwrvgnd_1
XFILLER_10_178 VPWR VGND VPWR VGND sky130_ef_sc_hd__decap_12
XFILLER_12_85 VGND VGND VPWR VPWR sky130_fd_sc_hd__decap_4
XTAP_TAPCELL_ROW_20_184 VGND VPWR sky130_fd_sc_hd__tapvpwrvgnd_1
XPHY_EDGE_ROW_25_Left_69 VGND VGND VPWR VPWR sky130_fd_sc_hd__decap_3
XPHY_EDGE_ROW_16_Right_16 VGND VGND VPWR VPWR sky130_fd_sc_hd__decap_3
XTAP_TAPCELL_ROW_43_287 VGND VPWR sky130_fd_sc_hd__tapvpwrvgnd_1
X_279_ bram.mem\[0\]\[6\] bram.mem\[1\]\[6\] bram.mem\[2\]\[6\] bram.mem\[3\]\[6\]
+ bram.raddr\[0\] bram.raddr\[1\] VGND VGND VPWR VPWR _161_ sky130_fd_sc_hd__mux4_1
XPHY_EDGE_ROW_25_Right_25 VGND VGND VPWR VPWR sky130_fd_sc_hd__decap_3
X_348_ bram.mem\[12\]\[0\] bram.mem\[13\]\[0\] bram.mem\[14\]\[0\] bram.mem\[15\]\[0\]
+ bram.raddr\[0\] bram.raddr\[1\] VGND VGND VPWR VPWR _208_ sky130_fd_sc_hd__mux4_1
X_417_ net4 bram.mem\[11\]\[1\] _239_ VGND VGND VPWR VPWR _041_ sky130_fd_sc_hd__mux2_1
XFILLER_5_193 VPWR VGND VPWR VGND sky130_ef_sc_hd__decap_12
XTAP_TAPCELL_ROW_3_108 VGND VPWR sky130_fd_sc_hd__tapvpwrvgnd_1
XPHY_EDGE_ROW_34_Right_34 VGND VGND VPWR VPWR sky130_fd_sc_hd__decap_3
XPHY_EDGE_ROW_43_Right_43 VGND VGND VPWR VPWR sky130_fd_sc_hd__decap_3
XFILLER_0_44 VPWR VGND VPWR VGND sky130_ef_sc_hd__decap_12
XTAP_TAPCELL_ROW_31_235 VGND VPWR sky130_fd_sc_hd__tapvpwrvgnd_1
X_682_ clknet_4_14_0_wclk _120_ VGND VGND VPWR VPWR bram.mem\[15\]\[0\] sky130_fd_sc_hd__dfxtp_1
XFILLER_34_61 VGND VGND VPWR VPWR sky130_fd_sc_hd__fill_2
XFILLER_34_83 VGND VGND VPWR VPWR sky130_fd_sc_hd__fill_1
XPHY_EDGE_ROW_28_Left_72 VGND VGND VPWR VPWR sky130_fd_sc_hd__decap_3
XPHY_EDGE_ROW_12_Left_56 VGND VGND VPWR VPWR sky130_fd_sc_hd__decap_3
XPHY_EDGE_ROW_2_Right_2 VGND VGND VPWR VPWR sky130_fd_sc_hd__decap_3
XFILLER_20_85 VPWR VGND VPWR VGND sky130_ef_sc_hd__decap_12
XFILLER_28_192 VGND VGND VPWR VPWR sky130_fd_sc_hd__decap_4
X_665_ clknet_1_1__leaf_rclk u_rptr_handler.g_rptr_next\[3\] net2 VGND VGND VPWR VPWR
+ r_ptr_gray\[3\] sky130_fd_sc_hd__dfrtp_1
XFILLER_43_195 VGND VGND VPWR VPWR sky130_fd_sc_hd__fill_1
X_596_ clknet_4_10_0_wclk _052_ VGND VGND VPWR VPWR bram.mem\[10\]\[4\] sky130_fd_sc_hd__dfxtp_1
XFILLER_6_98 VGND VGND VPWR VPWR sky130_fd_sc_hd__decap_8
X_450_ bram.mem\[8\]\[6\] net9 _243_ VGND VGND VPWR VPWR _070_ sky130_fd_sc_hd__mux2_1
X_381_ net4 bram.mem\[9\]\[1\] _235_ VGND VGND VPWR VPWR _009_ sky130_fd_sc_hd__mux2_1
X_648_ clknet_4_2_0_wclk _095_ VGND VGND VPWR VPWR bram.mem\[6\]\[7\] sky130_fd_sc_hd__dfxtp_1
X_579_ clknet_4_15_0_wclk _035_ VGND VGND VPWR VPWR bram.mem\[12\]\[3\] sky130_fd_sc_hd__dfxtp_1
XFILLER_36_29 VGND VGND VPWR VPWR sky130_fd_sc_hd__decap_3
XFILLER_22_154 VGND VGND VPWR VPWR sky130_fd_sc_hd__fill_1
XTAP_TAPCELL_ROW_9_136 VGND VPWR sky130_fd_sc_hd__tapvpwrvgnd_1
X_502_ net6 bram.mem\[1\]\[3\] _250_ VGND VGND VPWR VPWR _115_ sky130_fd_sc_hd__mux2_1
X_433_ _138_ bram.waddr\[2\] VGND VGND VPWR VPWR _241_ sky130_fd_sc_hd__and2_2
X_295_ bram.waddr\[1\] _174_ VGND VGND VPWR VPWR _175_ sky130_fd_sc_hd__nor2_1
X_364_ bram.mem\[12\]\[2\] bram.mem\[13\]\[2\] bram.mem\[14\]\[2\] bram.mem\[15\]\[2\]
+ bram.raddr\[0\] bram.raddr\[1\] VGND VGND VPWR VPWR _222_ sky130_fd_sc_hd__mux4_1
XFILLER_36_246 VGND VGND VPWR VPWR sky130_fd_sc_hd__decap_6
XFILLER_10_168 VGND VGND VPWR VPWR sky130_fd_sc_hd__fill_1
XFILLER_10_102 VGND VGND VPWR VPWR sky130_fd_sc_hd__fill_1
XFILLER_5_3 VPWR VGND VPWR VGND sky130_ef_sc_hd__decap_12
XPHY_EDGE_ROW_0_Left_44 VGND VGND VPWR VPWR sky130_fd_sc_hd__decap_3
XTAP_TAPCELL_ROW_20_185 VGND VPWR sky130_fd_sc_hd__tapvpwrvgnd_1
X_416_ net3 bram.mem\[11\]\[0\] _239_ VGND VGND VPWR VPWR _040_ sky130_fd_sc_hd__mux2_1
XTAP_TAPCELL_ROW_43_288 VGND VPWR sky130_fd_sc_hd__tapvpwrvgnd_1
X_347_ bram.raddr\[2\] _206_ VGND VGND VPWR VPWR _207_ sky130_fd_sc_hd__or2_1
X_278_ bram.raddr\[2\] _159_ bram.raddr\[3\] VGND VGND VPWR VPWR _160_ sky130_fd_sc_hd__o21a_1
XFILLER_5_161 VGND VGND VPWR VPWR sky130_fd_sc_hd__decap_6
XFILLER_38_3 VGND VGND VPWR VPWR sky130_fd_sc_hd__decap_3
XTAP_TAPCELL_ROW_3_109 VGND VPWR sky130_fd_sc_hd__tapvpwrvgnd_1
XPHY_EDGE_ROW_42_Left_86 VGND VGND VPWR VPWR sky130_fd_sc_hd__decap_3
XFILLER_23_63 VGND VGND VPWR VPWR sky130_fd_sc_hd__fill_1
XFILLER_2_197 VPWR VGND VPWR VGND sky130_ef_sc_hd__decap_12
X_681_ clknet_4_3_0_wclk _119_ VGND VGND VPWR VPWR bram.mem\[1\]\[7\] sky130_fd_sc_hd__dfxtp_1
XFILLER_18_85 VGND VGND VPWR VPWR sky130_fd_sc_hd__decap_8
XFILLER_29_105 VGND VGND VPWR VPWR sky130_fd_sc_hd__decap_6
XFILLER_37_160 VGND VGND VPWR VPWR sky130_fd_sc_hd__decap_3
XFILLER_20_97 VPWR VGND VPWR VGND sky130_ef_sc_hd__decap_12
XFILLER_29_51 VGND VGND VPWR VPWR sky130_fd_sc_hd__decap_4
XFILLER_43_141 VGND VGND VPWR VPWR sky130_fd_sc_hd__fill_2
XFILLER_29_84 VGND VGND VPWR VPWR sky130_fd_sc_hd__decap_4
XFILLER_35_108 VGND VGND VPWR VPWR sky130_fd_sc_hd__decap_4
X_664_ clknet_1_0__leaf_rclk u_rptr_handler.g_rptr_next\[2\] net2 VGND VGND VPWR VPWR
+ r_ptr_gray\[2\] sky130_fd_sc_hd__dfrtp_1
X_595_ clknet_4_11_0_wclk _051_ VGND VGND VPWR VPWR bram.mem\[10\]\[3\] sky130_fd_sc_hd__dfxtp_1
XFILLER_43_174 VGND VGND VPWR VPWR sky130_fd_sc_hd__decap_4
XFILLER_6_77 VGND VGND VPWR VPWR sky130_fd_sc_hd__decap_3
Xclkbuf_4_3_0_wclk clknet_0_wclk VGND VGND VPWR VPWR clknet_4_3_0_wclk sky130_fd_sc_hd__clkbuf_8
XFILLER_20_3 VPWR VGND VPWR VGND sky130_ef_sc_hd__decap_12
XFILLER_19_182 VGND VGND VPWR VPWR sky130_fd_sc_hd__fill_1
X_380_ net3 bram.mem\[9\]\[0\] _235_ VGND VGND VPWR VPWR _008_ sky130_fd_sc_hd__mux2_1
XFILLER_31_63 VGND VGND VPWR VPWR sky130_fd_sc_hd__fill_1
X_647_ clknet_4_2_0_wclk _094_ VGND VGND VPWR VPWR bram.mem\[6\]\[6\] sky130_fd_sc_hd__dfxtp_1
XFILLER_16_141 VGND VGND VPWR VPWR sky130_fd_sc_hd__decap_8
X_578_ clknet_4_9_0_wclk _034_ VGND VGND VPWR VPWR bram.mem\[12\]\[2\] sky130_fd_sc_hd__dfxtp_1
XFILLER_31_111 VGND VGND VPWR VPWR sky130_fd_sc_hd__fill_1
Xclkbuf_4_11_0_wclk clknet_0_wclk VGND VGND VPWR VPWR clknet_4_11_0_wclk sky130_fd_sc_hd__clkbuf_8
.ends
